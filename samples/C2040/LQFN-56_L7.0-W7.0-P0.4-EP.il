/* Auto-generated by lcsc2cadence. 不要手改，重新生成即可。 */
(defun lcsc_build_footprint ()
  (let (dr padFigure)
    (axlOpenDesign ?design "LQFN-56_L7.0-W7.0-P0.4-EP.dra" ?mode "wf" ?noMru t)
    (axlSetSymbolType "package")
    /* ---- padstacks ---- */
    (axlDBCreatePadStack "57"
      (list nil)
      (list
      (make_axlPadStackPad ?layer "TOP" ?figureSize "3.1000:3.1000")
      (make_axlPadStackPad ?layer "SOLDERMASK_TOP" ?figureSize "3.1000:3.1000")
      (make_axlPadStackPad ?layer "PASTEMASK_TOP" ?figureSize "3.1000:3.1000")
      )
    )
    (axlDBCreatePadStack "56"
      (list nil)
      (list
      (make_axlPadStackPad ?layer "TOP" ?figureSize "0.8500:0.2000")
      (make_axlPadStackPad ?layer "SOLDERMASK_TOP" ?figureSize "0.8500:0.2000")
      (make_axlPadStackPad ?layer "PASTEMASK_TOP" ?figureSize "0.8500:0.2000")
      )
    )
    (axlDBCreatePadStack "55"
      (list nil)
      (list
      (make_axlPadStackPad ?layer "TOP" ?figureSize "0.8500:0.2000")
      (make_axlPadStackPad ?layer "SOLDERMASK_TOP" ?figureSize "0.8500:0.2000")
      (make_axlPadStackPad ?layer "PASTEMASK_TOP" ?figureSize "0.8500:0.2000")
      )
    )
    (axlDBCreatePadStack "54"
      (list nil)
      (list
      (make_axlPadStackPad ?layer "TOP" ?figureSize "0.8500:0.2000")
      (make_axlPadStackPad ?layer "SOLDERMASK_TOP" ?figureSize "0.8500:0.2000")
      (make_axlPadStackPad ?layer "PASTEMASK_TOP" ?figureSize "0.8500:0.2000")
      )
    )
    (axlDBCreatePadStack "53"
      (list nil)
      (list
      (make_axlPadStackPad ?layer "TOP" ?figureSize "0.8500:0.2000")
      (make_axlPadStackPad ?layer "SOLDERMASK_TOP" ?figureSize "0.8500:0.2000")
      (make_axlPadStackPad ?layer "PASTEMASK_TOP" ?figureSize "0.8500:0.2000")
      )
    )
    (axlDBCreatePadStack "52"
      (list nil)
      (list
      (make_axlPadStackPad ?layer "TOP" ?figureSize "0.8500:0.2000")
      (make_axlPadStackPad ?layer "SOLDERMASK_TOP" ?figureSize "0.8500:0.2000")
      (make_axlPadStackPad ?layer "PASTEMASK_TOP" ?figureSize "0.8500:0.2000")
      )
    )
    (axlDBCreatePadStack "51"
      (list nil)
      (list
      (make_axlPadStackPad ?layer "TOP" ?figureSize "0.8500:0.2000")
      (make_axlPadStackPad ?layer "SOLDERMASK_TOP" ?figureSize "0.8500:0.2000")
      (make_axlPadStackPad ?layer "PASTEMASK_TOP" ?figureSize "0.8500:0.2000")
      )
    )
    (axlDBCreatePadStack "50"
      (list nil)
      (list
      (make_axlPadStackPad ?layer "TOP" ?figureSize "0.8500:0.2000")
      (make_axlPadStackPad ?layer "SOLDERMASK_TOP" ?figureSize "0.8500:0.2000")
      (make_axlPadStackPad ?layer "PASTEMASK_TOP" ?figureSize "0.8500:0.2000")
      )
    )
    (axlDBCreatePadStack "49"
      (list nil)
      (list
      (make_axlPadStackPad ?layer "TOP" ?figureSize "0.8500:0.2000")
      (make_axlPadStackPad ?layer "SOLDERMASK_TOP" ?figureSize "0.8500:0.2000")
      (make_axlPadStackPad ?layer "PASTEMASK_TOP" ?figureSize "0.8500:0.2000")
      )
    )
    (axlDBCreatePadStack "48"
      (list nil)
      (list
      (make_axlPadStackPad ?layer "TOP" ?figureSize "0.8500:0.2000")
      (make_axlPadStackPad ?layer "SOLDERMASK_TOP" ?figureSize "0.8500:0.2000")
      (make_axlPadStackPad ?layer "PASTEMASK_TOP" ?figureSize "0.8500:0.2000")
      )
    )
    (axlDBCreatePadStack "47"
      (list nil)
      (list
      (make_axlPadStackPad ?layer "TOP" ?figureSize "0.8500:0.2000")
      (make_axlPadStackPad ?layer "SOLDERMASK_TOP" ?figureSize "0.8500:0.2000")
      (make_axlPadStackPad ?layer "PASTEMASK_TOP" ?figureSize "0.8500:0.2000")
      )
    )
    (axlDBCreatePadStack "46"
      (list nil)
      (list
      (make_axlPadStackPad ?layer "TOP" ?figureSize "0.8500:0.2000")
      (make_axlPadStackPad ?layer "SOLDERMASK_TOP" ?figureSize "0.8500:0.2000")
      (make_axlPadStackPad ?layer "PASTEMASK_TOP" ?figureSize "0.8500:0.2000")
      )
    )
    (axlDBCreatePadStack "45"
      (list nil)
      (list
      (make_axlPadStackPad ?layer "TOP" ?figureSize "0.8500:0.2000")
      (make_axlPadStackPad ?layer "SOLDERMASK_TOP" ?figureSize "0.8500:0.2000")
      (make_axlPadStackPad ?layer "PASTEMASK_TOP" ?figureSize "0.8500:0.2000")
      )
    )
    (axlDBCreatePadStack "44"
      (list nil)
      (list
      (make_axlPadStackPad ?layer "TOP" ?figureSize "0.8500:0.2000")
      (make_axlPadStackPad ?layer "SOLDERMASK_TOP" ?figureSize "0.8500:0.2000")
      (make_axlPadStackPad ?layer "PASTEMASK_TOP" ?figureSize "0.8500:0.2000")
      )
    )
    (axlDBCreatePadStack "43"
      (list nil)
      (list
      (make_axlPadStackPad ?layer "TOP" ?figureSize "0.8500:0.2000")
      (make_axlPadStackPad ?layer "SOLDERMASK_TOP" ?figureSize "0.8500:0.2000")
      (make_axlPadStackPad ?layer "PASTEMASK_TOP" ?figureSize "0.8500:0.2000")
      )
    )
    (axlDBCreatePadStack "42"
      (list nil)
      (list
      (make_axlPadStackPad ?layer "TOP" ?figureSize "0.8500:0.2000")
      (make_axlPadStackPad ?layer "SOLDERMASK_TOP" ?figureSize "0.8500:0.2000")
      (make_axlPadStackPad ?layer "PASTEMASK_TOP" ?figureSize "0.8500:0.2000")
      )
    )
    (axlDBCreatePadStack "41"
      (list nil)
      (list
      (make_axlPadStackPad ?layer "TOP" ?figureSize "0.8500:0.2000")
      (make_axlPadStackPad ?layer "SOLDERMASK_TOP" ?figureSize "0.8500:0.2000")
      (make_axlPadStackPad ?layer "PASTEMASK_TOP" ?figureSize "0.8500:0.2000")
      )
    )
    (axlDBCreatePadStack "40"
      (list nil)
      (list
      (make_axlPadStackPad ?layer "TOP" ?figureSize "0.8500:0.2000")
      (make_axlPadStackPad ?layer "SOLDERMASK_TOP" ?figureSize "0.8500:0.2000")
      (make_axlPadStackPad ?layer "PASTEMASK_TOP" ?figureSize "0.8500:0.2000")
      )
    )
    (axlDBCreatePadStack "39"
      (list nil)
      (list
      (make_axlPadStackPad ?layer "TOP" ?figureSize "0.8500:0.2000")
      (make_axlPadStackPad ?layer "SOLDERMASK_TOP" ?figureSize "0.8500:0.2000")
      (make_axlPadStackPad ?layer "PASTEMASK_TOP" ?figureSize "0.8500:0.2000")
      )
    )
    (axlDBCreatePadStack "38"
      (list nil)
      (list
      (make_axlPadStackPad ?layer "TOP" ?figureSize "0.8500:0.2000")
      (make_axlPadStackPad ?layer "SOLDERMASK_TOP" ?figureSize "0.8500:0.2000")
      (make_axlPadStackPad ?layer "PASTEMASK_TOP" ?figureSize "0.8500:0.2000")
      )
    )
    (axlDBCreatePadStack "37"
      (list nil)
      (list
      (make_axlPadStackPad ?layer "TOP" ?figureSize "0.8500:0.2000")
      (make_axlPadStackPad ?layer "SOLDERMASK_TOP" ?figureSize "0.8500:0.2000")
      (make_axlPadStackPad ?layer "PASTEMASK_TOP" ?figureSize "0.8500:0.2000")
      )
    )
    (axlDBCreatePadStack "36"
      (list nil)
      (list
      (make_axlPadStackPad ?layer "TOP" ?figureSize "0.8500:0.2000")
      (make_axlPadStackPad ?layer "SOLDERMASK_TOP" ?figureSize "0.8500:0.2000")
      (make_axlPadStackPad ?layer "PASTEMASK_TOP" ?figureSize "0.8500:0.2000")
      )
    )
    (axlDBCreatePadStack "35"
      (list nil)
      (list
      (make_axlPadStackPad ?layer "TOP" ?figureSize "0.8500:0.2000")
      (make_axlPadStackPad ?layer "SOLDERMASK_TOP" ?figureSize "0.8500:0.2000")
      (make_axlPadStackPad ?layer "PASTEMASK_TOP" ?figureSize "0.8500:0.2000")
      )
    )
    (axlDBCreatePadStack "34"
      (list nil)
      (list
      (make_axlPadStackPad ?layer "TOP" ?figureSize "0.8500:0.2000")
      (make_axlPadStackPad ?layer "SOLDERMASK_TOP" ?figureSize "0.8500:0.2000")
      (make_axlPadStackPad ?layer "PASTEMASK_TOP" ?figureSize "0.8500:0.2000")
      )
    )
    (axlDBCreatePadStack "33"
      (list nil)
      (list
      (make_axlPadStackPad ?layer "TOP" ?figureSize "0.8500:0.2000")
      (make_axlPadStackPad ?layer "SOLDERMASK_TOP" ?figureSize "0.8500:0.2000")
      (make_axlPadStackPad ?layer "PASTEMASK_TOP" ?figureSize "0.8500:0.2000")
      )
    )
    (axlDBCreatePadStack "32"
      (list nil)
      (list
      (make_axlPadStackPad ?layer "TOP" ?figureSize "0.8500:0.2000")
      (make_axlPadStackPad ?layer "SOLDERMASK_TOP" ?figureSize "0.8500:0.2000")
      (make_axlPadStackPad ?layer "PASTEMASK_TOP" ?figureSize "0.8500:0.2000")
      )
    )
    (axlDBCreatePadStack "31"
      (list nil)
      (list
      (make_axlPadStackPad ?layer "TOP" ?figureSize "0.8500:0.2000")
      (make_axlPadStackPad ?layer "SOLDERMASK_TOP" ?figureSize "0.8500:0.2000")
      (make_axlPadStackPad ?layer "PASTEMASK_TOP" ?figureSize "0.8500:0.2000")
      )
    )
    (axlDBCreatePadStack "30"
      (list nil)
      (list
      (make_axlPadStackPad ?layer "TOP" ?figureSize "0.8500:0.2000")
      (make_axlPadStackPad ?layer "SOLDERMASK_TOP" ?figureSize "0.8500:0.2000")
      (make_axlPadStackPad ?layer "PASTEMASK_TOP" ?figureSize "0.8500:0.2000")
      )
    )
    (axlDBCreatePadStack "29"
      (list nil)
      (list
      (make_axlPadStackPad ?layer "TOP" ?figureSize "0.8500:0.2000")
      (make_axlPadStackPad ?layer "SOLDERMASK_TOP" ?figureSize "0.8500:0.2000")
      (make_axlPadStackPad ?layer "PASTEMASK_TOP" ?figureSize "0.8500:0.2000")
      )
    )
    (axlDBCreatePadStack "28"
      (list nil)
      (list
      (make_axlPadStackPad ?layer "TOP" ?figureSize "0.8500:0.2000")
      (make_axlPadStackPad ?layer "SOLDERMASK_TOP" ?figureSize "0.8500:0.2000")
      (make_axlPadStackPad ?layer "PASTEMASK_TOP" ?figureSize "0.8500:0.2000")
      )
    )
    (axlDBCreatePadStack "27"
      (list nil)
      (list
      (make_axlPadStackPad ?layer "TOP" ?figureSize "0.8500:0.2000")
      (make_axlPadStackPad ?layer "SOLDERMASK_TOP" ?figureSize "0.8500:0.2000")
      (make_axlPadStackPad ?layer "PASTEMASK_TOP" ?figureSize "0.8500:0.2000")
      )
    )
    (axlDBCreatePadStack "26"
      (list nil)
      (list
      (make_axlPadStackPad ?layer "TOP" ?figureSize "0.8500:0.2000")
      (make_axlPadStackPad ?layer "SOLDERMASK_TOP" ?figureSize "0.8500:0.2000")
      (make_axlPadStackPad ?layer "PASTEMASK_TOP" ?figureSize "0.8500:0.2000")
      )
    )
    (axlDBCreatePadStack "25"
      (list nil)
      (list
      (make_axlPadStackPad ?layer "TOP" ?figureSize "0.8500:0.2000")
      (make_axlPadStackPad ?layer "SOLDERMASK_TOP" ?figureSize "0.8500:0.2000")
      (make_axlPadStackPad ?layer "PASTEMASK_TOP" ?figureSize "0.8500:0.2000")
      )
    )
    (axlDBCreatePadStack "24"
      (list nil)
      (list
      (make_axlPadStackPad ?layer "TOP" ?figureSize "0.8500:0.2000")
      (make_axlPadStackPad ?layer "SOLDERMASK_TOP" ?figureSize "0.8500:0.2000")
      (make_axlPadStackPad ?layer "PASTEMASK_TOP" ?figureSize "0.8500:0.2000")
      )
    )
    (axlDBCreatePadStack "23"
      (list nil)
      (list
      (make_axlPadStackPad ?layer "TOP" ?figureSize "0.8500:0.2000")
      (make_axlPadStackPad ?layer "SOLDERMASK_TOP" ?figureSize "0.8500:0.2000")
      (make_axlPadStackPad ?layer "PASTEMASK_TOP" ?figureSize "0.8500:0.2000")
      )
    )
    (axlDBCreatePadStack "22"
      (list nil)
      (list
      (make_axlPadStackPad ?layer "TOP" ?figureSize "0.8500:0.2000")
      (make_axlPadStackPad ?layer "SOLDERMASK_TOP" ?figureSize "0.8500:0.2000")
      (make_axlPadStackPad ?layer "PASTEMASK_TOP" ?figureSize "0.8500:0.2000")
      )
    )
    (axlDBCreatePadStack "21"
      (list nil)
      (list
      (make_axlPadStackPad ?layer "TOP" ?figureSize "0.8500:0.2000")
      (make_axlPadStackPad ?layer "SOLDERMASK_TOP" ?figureSize "0.8500:0.2000")
      (make_axlPadStackPad ?layer "PASTEMASK_TOP" ?figureSize "0.8500:0.2000")
      )
    )
    (axlDBCreatePadStack "20"
      (list nil)
      (list
      (make_axlPadStackPad ?layer "TOP" ?figureSize "0.8500:0.2000")
      (make_axlPadStackPad ?layer "SOLDERMASK_TOP" ?figureSize "0.8500:0.2000")
      (make_axlPadStackPad ?layer "PASTEMASK_TOP" ?figureSize "0.8500:0.2000")
      )
    )
    (axlDBCreatePadStack "19"
      (list nil)
      (list
      (make_axlPadStackPad ?layer "TOP" ?figureSize "0.8500:0.2000")
      (make_axlPadStackPad ?layer "SOLDERMASK_TOP" ?figureSize "0.8500:0.2000")
      (make_axlPadStackPad ?layer "PASTEMASK_TOP" ?figureSize "0.8500:0.2000")
      )
    )
    (axlDBCreatePadStack "18"
      (list nil)
      (list
      (make_axlPadStackPad ?layer "TOP" ?figureSize "0.8500:0.2000")
      (make_axlPadStackPad ?layer "SOLDERMASK_TOP" ?figureSize "0.8500:0.2000")
      (make_axlPadStackPad ?layer "PASTEMASK_TOP" ?figureSize "0.8500:0.2000")
      )
    )
    (axlDBCreatePadStack "17"
      (list nil)
      (list
      (make_axlPadStackPad ?layer "TOP" ?figureSize "0.8500:0.2000")
      (make_axlPadStackPad ?layer "SOLDERMASK_TOP" ?figureSize "0.8500:0.2000")
      (make_axlPadStackPad ?layer "PASTEMASK_TOP" ?figureSize "0.8500:0.2000")
      )
    )
    (axlDBCreatePadStack "16"
      (list nil)
      (list
      (make_axlPadStackPad ?layer "TOP" ?figureSize "0.8500:0.2000")
      (make_axlPadStackPad ?layer "SOLDERMASK_TOP" ?figureSize "0.8500:0.2000")
      (make_axlPadStackPad ?layer "PASTEMASK_TOP" ?figureSize "0.8500:0.2000")
      )
    )
    (axlDBCreatePadStack "15"
      (list nil)
      (list
      (make_axlPadStackPad ?layer "TOP" ?figureSize "0.8500:0.2000")
      (make_axlPadStackPad ?layer "SOLDERMASK_TOP" ?figureSize "0.8500:0.2000")
      (make_axlPadStackPad ?layer "PASTEMASK_TOP" ?figureSize "0.8500:0.2000")
      )
    )
    (axlDBCreatePadStack "14"
      (list nil)
      (list
      (make_axlPadStackPad ?layer "TOP" ?figureSize "0.8500:0.2000")
      (make_axlPadStackPad ?layer "SOLDERMASK_TOP" ?figureSize "0.8500:0.2000")
      (make_axlPadStackPad ?layer "PASTEMASK_TOP" ?figureSize "0.8500:0.2000")
      )
    )
    (axlDBCreatePadStack "13"
      (list nil)
      (list
      (make_axlPadStackPad ?layer "TOP" ?figureSize "0.8500:0.2000")
      (make_axlPadStackPad ?layer "SOLDERMASK_TOP" ?figureSize "0.8500:0.2000")
      (make_axlPadStackPad ?layer "PASTEMASK_TOP" ?figureSize "0.8500:0.2000")
      )
    )
    (axlDBCreatePadStack "12"
      (list nil)
      (list
      (make_axlPadStackPad ?layer "TOP" ?figureSize "0.8500:0.2000")
      (make_axlPadStackPad ?layer "SOLDERMASK_TOP" ?figureSize "0.8500:0.2000")
      (make_axlPadStackPad ?layer "PASTEMASK_TOP" ?figureSize "0.8500:0.2000")
      )
    )
    (axlDBCreatePadStack "11"
      (list nil)
      (list
      (make_axlPadStackPad ?layer "TOP" ?figureSize "0.8500:0.2000")
      (make_axlPadStackPad ?layer "SOLDERMASK_TOP" ?figureSize "0.8500:0.2000")
      (make_axlPadStackPad ?layer "PASTEMASK_TOP" ?figureSize "0.8500:0.2000")
      )
    )
    (axlDBCreatePadStack "10"
      (list nil)
      (list
      (make_axlPadStackPad ?layer "TOP" ?figureSize "0.8500:0.2000")
      (make_axlPadStackPad ?layer "SOLDERMASK_TOP" ?figureSize "0.8500:0.2000")
      (make_axlPadStackPad ?layer "PASTEMASK_TOP" ?figureSize "0.8500:0.2000")
      )
    )
    (axlDBCreatePadStack "9"
      (list nil)
      (list
      (make_axlPadStackPad ?layer "TOP" ?figureSize "0.8500:0.2000")
      (make_axlPadStackPad ?layer "SOLDERMASK_TOP" ?figureSize "0.8500:0.2000")
      (make_axlPadStackPad ?layer "PASTEMASK_TOP" ?figureSize "0.8500:0.2000")
      )
    )
    (axlDBCreatePadStack "8"
      (list nil)
      (list
      (make_axlPadStackPad ?layer "TOP" ?figureSize "0.8500:0.2000")
      (make_axlPadStackPad ?layer "SOLDERMASK_TOP" ?figureSize "0.8500:0.2000")
      (make_axlPadStackPad ?layer "PASTEMASK_TOP" ?figureSize "0.8500:0.2000")
      )
    )
    (axlDBCreatePadStack "7"
      (list nil)
      (list
      (make_axlPadStackPad ?layer "TOP" ?figureSize "0.8500:0.2000")
      (make_axlPadStackPad ?layer "SOLDERMASK_TOP" ?figureSize "0.8500:0.2000")
      (make_axlPadStackPad ?layer "PASTEMASK_TOP" ?figureSize "0.8500:0.2000")
      )
    )
    (axlDBCreatePadStack "6"
      (list nil)
      (list
      (make_axlPadStackPad ?layer "TOP" ?figureSize "0.8500:0.2000")
      (make_axlPadStackPad ?layer "SOLDERMASK_TOP" ?figureSize "0.8500:0.2000")
      (make_axlPadStackPad ?layer "PASTEMASK_TOP" ?figureSize "0.8500:0.2000")
      )
    )
    (axlDBCreatePadStack "5"
      (list nil)
      (list
      (make_axlPadStackPad ?layer "TOP" ?figureSize "0.8500:0.2000")
      (make_axlPadStackPad ?layer "SOLDERMASK_TOP" ?figureSize "0.8500:0.2000")
      (make_axlPadStackPad ?layer "PASTEMASK_TOP" ?figureSize "0.8500:0.2000")
      )
    )
    (axlDBCreatePadStack "4"
      (list nil)
      (list
      (make_axlPadStackPad ?layer "TOP" ?figureSize "0.8500:0.2000")
      (make_axlPadStackPad ?layer "SOLDERMASK_TOP" ?figureSize "0.8500:0.2000")
      (make_axlPadStackPad ?layer "PASTEMASK_TOP" ?figureSize "0.8500:0.2000")
      )
    )
    (axlDBCreatePadStack "3"
      (list nil)
      (list
      (make_axlPadStackPad ?layer "TOP" ?figureSize "0.8500:0.2000")
      (make_axlPadStackPad ?layer "SOLDERMASK_TOP" ?figureSize "0.8500:0.2000")
      (make_axlPadStackPad ?layer "PASTEMASK_TOP" ?figureSize "0.8500:0.2000")
      )
    )
    (axlDBCreatePadStack "2"
      (list nil)
      (list
      (make_axlPadStackPad ?layer "TOP" ?figureSize "0.8500:0.2000")
      (make_axlPadStackPad ?layer "SOLDERMASK_TOP" ?figureSize "0.8500:0.2000")
      (make_axlPadStackPad ?layer "PASTEMASK_TOP" ?figureSize "0.8500:0.2000")
      )
    )
    (axlDBCreatePadStack "1"
      (list nil)
      (list
      (make_axlPadStackPad ?layer "TOP" ?figureSize "0.8500:0.2000")
      (make_axlPadStackPad ?layer "SOLDERMASK_TOP" ?figureSize "0.8500:0.2000")
      (make_axlPadStackPad ?layer "PASTEMASK_TOP" ?figureSize "0.8500:0.2000")
      )
    )
    /* ---- pins ---- */
    (axlDBCreatePin (list "57") (list 0.0000 0.0000) (make_axlPinText ?text "57" ?orientation (make_axlTextOrientation ?textAngle 0.0)) 0.00)
    (axlDBCreatePin (list "56") (list -2.5999 -3.4249) (make_axlPinText ?text "56" ?orientation (make_axlTextOrientation ?textAngle 0.0)) 270.00)
    (axlDBCreatePin (list "55") (list -2.2001 -3.4249) (make_axlPinText ?text "55" ?orientation (make_axlTextOrientation ?textAngle 0.0)) 270.00)
    (axlDBCreatePin (list "54") (list -1.8001 -3.4249) (make_axlPinText ?text "54" ?orientation (make_axlTextOrientation ?textAngle 0.0)) 270.00)
    (axlDBCreatePin (list "53") (list -1.4000 -3.4249) (make_axlPinText ?text "53" ?orientation (make_axlTextOrientation ?textAngle 0.0)) 270.00)
    (axlDBCreatePin (list "52") (list -1.0000 -3.4249) (make_axlPinText ?text "52" ?orientation (make_axlTextOrientation ?textAngle 0.0)) 270.00)
    (axlDBCreatePin (list "51") (list -0.5999 -3.4249) (make_axlPinText ?text "51" ?orientation (make_axlTextOrientation ?textAngle 0.0)) 270.00)
    (axlDBCreatePin (list "50") (list -0.2002 -3.4249) (make_axlPinText ?text "50" ?orientation (make_axlTextOrientation ?textAngle 0.0)) 270.00)
    (axlDBCreatePin (list "49") (list 0.1999 -3.4249) (make_axlPinText ?text "49" ?orientation (make_axlTextOrientation ?textAngle 0.0)) 270.00)
    (axlDBCreatePin (list "48") (list 0.5999 -3.4249) (make_axlPinText ?text "48" ?orientation (make_axlTextOrientation ?textAngle 0.0)) 270.00)
    (axlDBCreatePin (list "47") (list 1.0000 -3.4249) (make_axlPinText ?text "47" ?orientation (make_axlTextOrientation ?textAngle 0.0)) 270.00)
    (axlDBCreatePin (list "46") (list 1.4000 -3.4249) (make_axlPinText ?text "46" ?orientation (make_axlTextOrientation ?textAngle 0.0)) 270.00)
    (axlDBCreatePin (list "45") (list 1.7998 -3.4249) (make_axlPinText ?text "45" ?orientation (make_axlTextOrientation ?textAngle 0.0)) 270.00)
    (axlDBCreatePin (list "44") (list 2.1999 -3.4249) (make_axlPinText ?text "44" ?orientation (make_axlTextOrientation ?textAngle 0.0)) 270.00)
    (axlDBCreatePin (list "43") (list 2.5999 -3.4249) (make_axlPinText ?text "43" ?orientation (make_axlTextOrientation ?textAngle 0.0)) 270.00)
    (axlDBCreatePin (list "42") (list 3.4249 -2.5999) (make_axlPinText ?text "42" ?orientation (make_axlTextOrientation ?textAngle 0.0)) 180.00)
    (axlDBCreatePin (list "41") (list 3.4249 -2.1999) (make_axlPinText ?text "41" ?orientation (make_axlTextOrientation ?textAngle 0.0)) 180.00)
    (axlDBCreatePin (list "40") (list 3.4249 -1.7998) (make_axlPinText ?text "40" ?orientation (make_axlTextOrientation ?textAngle 0.0)) 180.00)
    (axlDBCreatePin (list "39") (list 3.4249 -1.3998) (make_axlPinText ?text "39" ?orientation (make_axlTextOrientation ?textAngle 0.0)) 180.00)
    (axlDBCreatePin (list "38") (list 3.4249 -1.0000) (make_axlPinText ?text "38" ?orientation (make_axlTextOrientation ?textAngle 0.0)) 180.00)
    (axlDBCreatePin (list "37") (list 3.4249 -0.5999) (make_axlPinText ?text "37" ?orientation (make_axlTextOrientation ?textAngle 0.0)) 180.00)
    (axlDBCreatePin (list "36") (list 3.4249 -0.1999) (make_axlPinText ?text "36" ?orientation (make_axlTextOrientation ?textAngle 0.0)) 180.00)
    (axlDBCreatePin (list "35") (list 3.4249 0.2002) (make_axlPinText ?text "35" ?orientation (make_axlTextOrientation ?textAngle 0.0)) 180.00)
    (axlDBCreatePin (list "34") (list 3.4249 0.6002) (make_axlPinText ?text "34" ?orientation (make_axlTextOrientation ?textAngle 0.0)) 180.00)
    (axlDBCreatePin (list "33") (list 3.4249 1.0000) (make_axlPinText ?text "33" ?orientation (make_axlTextOrientation ?textAngle 0.0)) 180.00)
    (axlDBCreatePin (list "32") (list 3.4249 1.4000) (make_axlPinText ?text "32" ?orientation (make_axlTextOrientation ?textAngle 0.0)) 180.00)
    (axlDBCreatePin (list "31") (list 3.4249 1.8001) (make_axlPinText ?text "31" ?orientation (make_axlTextOrientation ?textAngle 0.0)) 180.00)
    (axlDBCreatePin (list "30") (list 3.4249 2.2001) (make_axlPinText ?text "30" ?orientation (make_axlTextOrientation ?textAngle 0.0)) 180.00)
    (axlDBCreatePin (list "29") (list 3.4249 2.6002) (make_axlPinText ?text "29" ?orientation (make_axlTextOrientation ?textAngle 0.0)) 180.00)
    (axlDBCreatePin (list "28") (list 2.5999 3.4252) (make_axlPinText ?text "28" ?orientation (make_axlTextOrientation ?textAngle 0.0)) 90.00)
    (axlDBCreatePin (list "27") (list 2.1999 3.4252) (make_axlPinText ?text "27" ?orientation (make_axlTextOrientation ?textAngle 0.0)) 90.00)
    (axlDBCreatePin (list "26") (list 1.7998 3.4252) (make_axlPinText ?text "26" ?orientation (make_axlTextOrientation ?textAngle 0.0)) 90.00)
    (axlDBCreatePin (list "25") (list 1.4000 3.4252) (make_axlPinText ?text "25" ?orientation (make_axlTextOrientation ?textAngle 0.0)) 90.00)
    (axlDBCreatePin (list "24") (list 1.0000 3.4252) (make_axlPinText ?text "24" ?orientation (make_axlTextOrientation ?textAngle 0.0)) 90.00)
    (axlDBCreatePin (list "23") (list 0.5999 3.4252) (make_axlPinText ?text "23" ?orientation (make_axlTextOrientation ?textAngle 0.0)) 90.00)
    (axlDBCreatePin (list "22") (list 0.1999 3.4252) (make_axlPinText ?text "22" ?orientation (make_axlTextOrientation ?textAngle 0.0)) 90.00)
    (axlDBCreatePin (list "21") (list -0.2002 3.4252) (make_axlPinText ?text "21" ?orientation (make_axlTextOrientation ?textAngle 0.0)) 90.00)
    (axlDBCreatePin (list "20") (list -0.5999 3.4252) (make_axlPinText ?text "20" ?orientation (make_axlTextOrientation ?textAngle 0.0)) 90.00)
    (axlDBCreatePin (list "19") (list -1.0000 3.4252) (make_axlPinText ?text "19" ?orientation (make_axlTextOrientation ?textAngle 0.0)) 90.00)
    (axlDBCreatePin (list "18") (list -1.4000 3.4252) (make_axlPinText ?text "18" ?orientation (make_axlTextOrientation ?textAngle 0.0)) 90.00)
    (axlDBCreatePin (list "17") (list -1.8001 3.4252) (make_axlPinText ?text "17" ?orientation (make_axlTextOrientation ?textAngle 0.0)) 90.00)
    (axlDBCreatePin (list "16") (list -2.2001 3.4252) (make_axlPinText ?text "16" ?orientation (make_axlTextOrientation ?textAngle 0.0)) 90.00)
    (axlDBCreatePin (list "15") (list -2.5999 3.4252) (make_axlPinText ?text "15" ?orientation (make_axlTextOrientation ?textAngle 0.0)) 90.00)
    (axlDBCreatePin (list "14") (list -3.4249 2.6002) (make_axlPinText ?text "14" ?orientation (make_axlTextOrientation ?textAngle 0.0)) 0.00)
    (axlDBCreatePin (list "13") (list -3.4249 2.2001) (make_axlPinText ?text "13" ?orientation (make_axlTextOrientation ?textAngle 0.0)) 0.00)
    (axlDBCreatePin (list "12") (list -3.4249 1.8001) (make_axlPinText ?text "12" ?orientation (make_axlTextOrientation ?textAngle 0.0)) 0.00)
    (axlDBCreatePin (list "11") (list -3.4249 1.4000) (make_axlPinText ?text "11" ?orientation (make_axlTextOrientation ?textAngle 0.0)) 0.00)
    (axlDBCreatePin (list "10") (list -3.4249 1.0000) (make_axlPinText ?text "10" ?orientation (make_axlTextOrientation ?textAngle 0.0)) 0.00)
    (axlDBCreatePin (list "9") (list -3.4249 0.6002) (make_axlPinText ?text "9" ?orientation (make_axlTextOrientation ?textAngle 0.0)) 0.00)
    (axlDBCreatePin (list "8") (list -3.4249 0.2002) (make_axlPinText ?text "8" ?orientation (make_axlTextOrientation ?textAngle 0.0)) 0.00)
    (axlDBCreatePin (list "7") (list -3.4249 -0.1999) (make_axlPinText ?text "7" ?orientation (make_axlTextOrientation ?textAngle 0.0)) 0.00)
    (axlDBCreatePin (list "6") (list -3.4249 -0.5999) (make_axlPinText ?text "6" ?orientation (make_axlTextOrientation ?textAngle 0.0)) 0.00)
    (axlDBCreatePin (list "5") (list -3.4249 -1.0000) (make_axlPinText ?text "5" ?orientation (make_axlTextOrientation ?textAngle 0.0)) 0.00)
    (axlDBCreatePin (list "4") (list -3.4249 -1.3998) (make_axlPinText ?text "4" ?orientation (make_axlTextOrientation ?textAngle 0.0)) 0.00)
    (axlDBCreatePin (list "3") (list -3.4249 -1.7998) (make_axlPinText ?text "3" ?orientation (make_axlTextOrientation ?textAngle 0.0)) 0.00)
    (axlDBCreatePin (list "2") (list -3.4249 -2.1999) (make_axlPinText ?text "2" ?orientation (make_axlTextOrientation ?textAngle 0.0)) 0.00)
    (axlDBCreatePin (list "1") (list -3.4249 -2.5999) (make_axlPinText ?text "1" ?orientation (make_axlTextOrientation ?textAngle 0.0)) 0.00)
    /* ---- silkscreen ---- */
    (axlDBCreateLine (list -3.2410 -3.4999 -3.2410 -3.4030 -3.5001 -3.1439) "PACKAGE GEOMETRY/SILKSCREEN_TOP" 0.12)
    (axlDBCreateLine (list -3.5001 -2.9311 -2.9312 -3.4999) "PACKAGE GEOMETRY/SILKSCREEN_TOP" 0.12)
    (axlDBCreateLine (list -3.5001 -2.9311 -3.5001 -3.4999) "PACKAGE GEOMETRY/SILKSCREEN_TOP" 0.12)
    (axlDBCreateLine (list -2.9312 3.5000 -3.4000 3.5000 -3.5001 3.5000 -3.5001 2.9312) "PACKAGE GEOMETRY/SILKSCREEN_TOP" 0.12)
    (axlDBCreateLine (list 3.4999 2.9312 3.4999 3.5000 2.9311 3.5000) "PACKAGE GEOMETRY/SILKSCREEN_TOP" 0.12)
    (axlDBCreateLine (list 2.9311 -3.4999 3.4999 -3.4999 3.4999 -2.9311) "PACKAGE GEOMETRY/SILKSCREEN_TOP" 0.12)
    (axlDBCreateLine (list -3.5001 -3.4999 -2.9312 -3.4999) "PACKAGE GEOMETRY/SILKSCREEN_TOP" 0.12)
    (axlDBCreateLine (list -3.2410 -3.5000 -3.2410 -3.4032 -3.5001 -3.1441) "PACKAGE GEOMETRY/SILKSCREEN_TOP" 0.12)
    (axlDBCreateLine (list -3.5001 -2.9312 -2.9312 -3.5000) "PACKAGE GEOMETRY/SILKSCREEN_TOP" 0.12)
    (axlDBCreateLine (list -3.5001 -2.9312 -3.5001 -3.5000) "PACKAGE GEOMETRY/SILKSCREEN_TOP" 0.12)
    (axlDBCreateLine (list -2.9312 3.4999 -3.4000 3.4999 -3.5001 3.4999 -3.5001 2.9311) "PACKAGE GEOMETRY/SILKSCREEN_TOP" 0.12)
    (axlDBCreateLine (list 3.4999 2.9311 3.4999 3.4999 2.9311 3.4999) "PACKAGE GEOMETRY/SILKSCREEN_TOP" 0.12)
    (axlDBCreateLine (list 2.9311 -3.5000 3.4999 -3.5000 3.4999 -2.9312) "PACKAGE GEOMETRY/SILKSCREEN_TOP" 0.12)
    (axlDBCreateLine (list -3.5001 -3.5000 -2.9312 -3.5000) "PACKAGE GEOMETRY/SILKSCREEN_TOP" 0.12)
    (axlDBCreateCircle (list -4.0000 -3.7001) 0.1270 "PACKAGE GEOMETRY/SILKSCREEN_TOP")
    (axlDBCreateCircle (list -4.0000 -3.7000) 0.1270 "PACKAGE GEOMETRY/SILKSCREEN_TOP")
    /* ---- place bound ---- */
    (axlDBCreateShape (list -4.0499 -3.7249 4.0499 -3.7249 4.0499 3.7252 -4.0499 3.7252 -4.0499 -3.7249) "PACKAGE GEOMETRY/PLACE_BOUND_TOP")
    /* ---- save & compile ---- */
    (axlSaveDesign ?design ?mode "nocheck" ?noMru t)
    (axlCompileSymbol ?symbol "package")
  )
)

(lcsc_build_footprint)
