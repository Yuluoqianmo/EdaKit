/* EdaKit M4 candidate. Load in a separate Allegro symbol editor. */
(defun lcsc_build_footprint ()
  (let ()
    (when (isFile "E:/outputs/edakit/samples/C2040/LQFN-56_L7.0-W7.0-P0.4-EP.dra") (error "EdaKit: output already exists"))
    (when (isFile "E:/outputs/edakit/samples/C2040/LQFN-56_L7.0-W7.0-P0.4-EP.psm") (error "EdaKit: output already exists"))
    (unless (axlOpenDesign ?design "E:/outputs/edakit/samples/C2040/LQFN-56_L7.0-W7.0-P0.4-EP.dra" ?mode "w" ?noMru t) (error "EdaKit: open design failed"))
    (unless (axlSetSymbolType "package") (error "EdaKit: symbol type failed"))
    (unless (axlDBChangeDesignUnits "millimeters" 4) (error "EdaKit: units failed"))
    (unless (axlDBChangeDesignExtents (list -14.3270:-14.0499 14.0499:14.0502)) (error "EdaKit: drawing extents failed"))
    (unless (axlDBCreatePadStack "EK_94b4f8b90cd84e3864be" nil (list (make_axlPadStackPad ?layer "TOP" ?type 'REGULAR ?figure 'RECTANGLE ?figureSize 3.1000:3.1000) (make_axlPadStackPad ?layer "SOLDERMASK_TOP" ?type 'REGULAR ?figure 'RECTANGLE ?figureSize 3.1000:3.1000) (make_axlPadStackPad ?layer "PASTEMASK_TOP" ?type 'REGULAR ?figure 'RECTANGLE ?figureSize 3.1000:3.1000))) (error "EdaKit: create padstack failed"))
    (unless (isFile "E:/outputs/edakit/samples/C2040/EK_94b4f8b90cd84e3864be.pad")
    (unless (axlPadstackToDisk "EK_94b4f8b90cd84e3864be" "E:/outputs/edakit/samples/C2040/EK_94b4f8b90cd84e3864be.pad") (error "EdaKit: save padstack failed"))
    )
    (unless (axlDBCreatePin "EK_94b4f8b90cd84e3864be" 0.0000:0.0000 (make_axlPinText ?number "57" ?offset 0:0 ?text (make_axlTextOrientation ?textBlock 1 ?rotation 0.0 ?justify "center")) 0.0000) (error "EdaKit: create pin failed"))
    (unless (axlDBCreatePadStack "EK_72c972d9b5be27d52b98" nil (list (make_axlPadStackPad ?layer "TOP" ?type 'REGULAR ?figure 'RECTANGLE ?figureSize 0.8500:0.2000) (make_axlPadStackPad ?layer "SOLDERMASK_TOP" ?type 'REGULAR ?figure 'RECTANGLE ?figureSize 0.8500:0.2000) (make_axlPadStackPad ?layer "PASTEMASK_TOP" ?type 'REGULAR ?figure 'RECTANGLE ?figureSize 0.8500:0.2000))) (error "EdaKit: create padstack failed"))
    (unless (isFile "E:/outputs/edakit/samples/C2040/EK_72c972d9b5be27d52b98.pad")
    (unless (axlPadstackToDisk "EK_72c972d9b5be27d52b98" "E:/outputs/edakit/samples/C2040/EK_72c972d9b5be27d52b98.pad") (error "EdaKit: save padstack failed"))
    )
    (unless (axlDBCreatePin "EK_72c972d9b5be27d52b98" -2.5999:-3.4249 (make_axlPinText ?number "56" ?offset 0:0 ?text (make_axlTextOrientation ?textBlock 1 ?rotation 0.0 ?justify "center")) 270.0000) (error "EdaKit: create pin failed"))
    (unless (axlDBCreatePadStack "EK_73f0ea7d147dd4df8b16" nil (list (make_axlPadStackPad ?layer "TOP" ?type 'REGULAR ?figure 'RECTANGLE ?figureSize 0.8500:0.2000) (make_axlPadStackPad ?layer "SOLDERMASK_TOP" ?type 'REGULAR ?figure 'RECTANGLE ?figureSize 0.8500:0.2000) (make_axlPadStackPad ?layer "PASTEMASK_TOP" ?type 'REGULAR ?figure 'RECTANGLE ?figureSize 0.8500:0.2000))) (error "EdaKit: create padstack failed"))
    (unless (isFile "E:/outputs/edakit/samples/C2040/EK_73f0ea7d147dd4df8b16.pad")
    (unless (axlPadstackToDisk "EK_73f0ea7d147dd4df8b16" "E:/outputs/edakit/samples/C2040/EK_73f0ea7d147dd4df8b16.pad") (error "EdaKit: save padstack failed"))
    )
    (unless (axlDBCreatePin "EK_73f0ea7d147dd4df8b16" -2.2001:-3.4249 (make_axlPinText ?number "55" ?offset 0:0 ?text (make_axlTextOrientation ?textBlock 1 ?rotation 0.0 ?justify "center")) 270.0000) (error "EdaKit: create pin failed"))
    (unless (axlDBCreatePadStack "EK_c760e7cccd671f94125c" nil (list (make_axlPadStackPad ?layer "TOP" ?type 'REGULAR ?figure 'RECTANGLE ?figureSize 0.8500:0.2000) (make_axlPadStackPad ?layer "SOLDERMASK_TOP" ?type 'REGULAR ?figure 'RECTANGLE ?figureSize 0.8500:0.2000) (make_axlPadStackPad ?layer "PASTEMASK_TOP" ?type 'REGULAR ?figure 'RECTANGLE ?figureSize 0.8500:0.2000))) (error "EdaKit: create padstack failed"))
    (unless (isFile "E:/outputs/edakit/samples/C2040/EK_c760e7cccd671f94125c.pad")
    (unless (axlPadstackToDisk "EK_c760e7cccd671f94125c" "E:/outputs/edakit/samples/C2040/EK_c760e7cccd671f94125c.pad") (error "EdaKit: save padstack failed"))
    )
    (unless (axlDBCreatePin "EK_c760e7cccd671f94125c" -1.8001:-3.4249 (make_axlPinText ?number "54" ?offset 0:0 ?text (make_axlTextOrientation ?textBlock 1 ?rotation 0.0 ?justify "center")) 270.0000) (error "EdaKit: create pin failed"))
    (unless (axlDBCreatePadStack "EK_bb8ad9462459d5404351" nil (list (make_axlPadStackPad ?layer "TOP" ?type 'REGULAR ?figure 'RECTANGLE ?figureSize 0.8500:0.2000) (make_axlPadStackPad ?layer "SOLDERMASK_TOP" ?type 'REGULAR ?figure 'RECTANGLE ?figureSize 0.8500:0.2000) (make_axlPadStackPad ?layer "PASTEMASK_TOP" ?type 'REGULAR ?figure 'RECTANGLE ?figureSize 0.8500:0.2000))) (error "EdaKit: create padstack failed"))
    (unless (isFile "E:/outputs/edakit/samples/C2040/EK_bb8ad9462459d5404351.pad")
    (unless (axlPadstackToDisk "EK_bb8ad9462459d5404351" "E:/outputs/edakit/samples/C2040/EK_bb8ad9462459d5404351.pad") (error "EdaKit: save padstack failed"))
    )
    (unless (axlDBCreatePin "EK_bb8ad9462459d5404351" -1.4000:-3.4249 (make_axlPinText ?number "53" ?offset 0:0 ?text (make_axlTextOrientation ?textBlock 1 ?rotation 0.0 ?justify "center")) 270.0000) (error "EdaKit: create pin failed"))
    (unless (axlDBCreatePadStack "EK_42bc6da7dcc21791b2b8" nil (list (make_axlPadStackPad ?layer "TOP" ?type 'REGULAR ?figure 'RECTANGLE ?figureSize 0.8500:0.2000) (make_axlPadStackPad ?layer "SOLDERMASK_TOP" ?type 'REGULAR ?figure 'RECTANGLE ?figureSize 0.8500:0.2000) (make_axlPadStackPad ?layer "PASTEMASK_TOP" ?type 'REGULAR ?figure 'RECTANGLE ?figureSize 0.8500:0.2000))) (error "EdaKit: create padstack failed"))
    (unless (isFile "E:/outputs/edakit/samples/C2040/EK_42bc6da7dcc21791b2b8.pad")
    (unless (axlPadstackToDisk "EK_42bc6da7dcc21791b2b8" "E:/outputs/edakit/samples/C2040/EK_42bc6da7dcc21791b2b8.pad") (error "EdaKit: save padstack failed"))
    )
    (unless (axlDBCreatePin "EK_42bc6da7dcc21791b2b8" -1.0000:-3.4249 (make_axlPinText ?number "52" ?offset 0:0 ?text (make_axlTextOrientation ?textBlock 1 ?rotation 0.0 ?justify "center")) 270.0000) (error "EdaKit: create pin failed"))
    (unless (axlDBCreatePadStack "EK_26afb938c22d2550f0aa" nil (list (make_axlPadStackPad ?layer "TOP" ?type 'REGULAR ?figure 'RECTANGLE ?figureSize 0.8500:0.2000) (make_axlPadStackPad ?layer "SOLDERMASK_TOP" ?type 'REGULAR ?figure 'RECTANGLE ?figureSize 0.8500:0.2000) (make_axlPadStackPad ?layer "PASTEMASK_TOP" ?type 'REGULAR ?figure 'RECTANGLE ?figureSize 0.8500:0.2000))) (error "EdaKit: create padstack failed"))
    (unless (isFile "E:/outputs/edakit/samples/C2040/EK_26afb938c22d2550f0aa.pad")
    (unless (axlPadstackToDisk "EK_26afb938c22d2550f0aa" "E:/outputs/edakit/samples/C2040/EK_26afb938c22d2550f0aa.pad") (error "EdaKit: save padstack failed"))
    )
    (unless (axlDBCreatePin "EK_26afb938c22d2550f0aa" -0.5999:-3.4249 (make_axlPinText ?number "51" ?offset 0:0 ?text (make_axlTextOrientation ?textBlock 1 ?rotation 0.0 ?justify "center")) 270.0000) (error "EdaKit: create pin failed"))
    (unless (axlDBCreatePadStack "EK_18ca29f8201ad867acaa" nil (list (make_axlPadStackPad ?layer "TOP" ?type 'REGULAR ?figure 'RECTANGLE ?figureSize 0.8500:0.2000) (make_axlPadStackPad ?layer "SOLDERMASK_TOP" ?type 'REGULAR ?figure 'RECTANGLE ?figureSize 0.8500:0.2000) (make_axlPadStackPad ?layer "PASTEMASK_TOP" ?type 'REGULAR ?figure 'RECTANGLE ?figureSize 0.8500:0.2000))) (error "EdaKit: create padstack failed"))
    (unless (isFile "E:/outputs/edakit/samples/C2040/EK_18ca29f8201ad867acaa.pad")
    (unless (axlPadstackToDisk "EK_18ca29f8201ad867acaa" "E:/outputs/edakit/samples/C2040/EK_18ca29f8201ad867acaa.pad") (error "EdaKit: save padstack failed"))
    )
    (unless (axlDBCreatePin "EK_18ca29f8201ad867acaa" -0.2002:-3.4249 (make_axlPinText ?number "50" ?offset 0:0 ?text (make_axlTextOrientation ?textBlock 1 ?rotation 0.0 ?justify "center")) 270.0000) (error "EdaKit: create pin failed"))
    (unless (axlDBCreatePadStack "EK_d6eca6b108c0bd5c3dad" nil (list (make_axlPadStackPad ?layer "TOP" ?type 'REGULAR ?figure 'RECTANGLE ?figureSize 0.8500:0.2000) (make_axlPadStackPad ?layer "SOLDERMASK_TOP" ?type 'REGULAR ?figure 'RECTANGLE ?figureSize 0.8500:0.2000) (make_axlPadStackPad ?layer "PASTEMASK_TOP" ?type 'REGULAR ?figure 'RECTANGLE ?figureSize 0.8500:0.2000))) (error "EdaKit: create padstack failed"))
    (unless (isFile "E:/outputs/edakit/samples/C2040/EK_d6eca6b108c0bd5c3dad.pad")
    (unless (axlPadstackToDisk "EK_d6eca6b108c0bd5c3dad" "E:/outputs/edakit/samples/C2040/EK_d6eca6b108c0bd5c3dad.pad") (error "EdaKit: save padstack failed"))
    )
    (unless (axlDBCreatePin "EK_d6eca6b108c0bd5c3dad" 0.1999:-3.4249 (make_axlPinText ?number "49" ?offset 0:0 ?text (make_axlTextOrientation ?textBlock 1 ?rotation 0.0 ?justify "center")) 270.0000) (error "EdaKit: create pin failed"))
    (unless (axlDBCreatePadStack "EK_251df20048757db6e75f" nil (list (make_axlPadStackPad ?layer "TOP" ?type 'REGULAR ?figure 'RECTANGLE ?figureSize 0.8500:0.2000) (make_axlPadStackPad ?layer "SOLDERMASK_TOP" ?type 'REGULAR ?figure 'RECTANGLE ?figureSize 0.8500:0.2000) (make_axlPadStackPad ?layer "PASTEMASK_TOP" ?type 'REGULAR ?figure 'RECTANGLE ?figureSize 0.8500:0.2000))) (error "EdaKit: create padstack failed"))
    (unless (isFile "E:/outputs/edakit/samples/C2040/EK_251df20048757db6e75f.pad")
    (unless (axlPadstackToDisk "EK_251df20048757db6e75f" "E:/outputs/edakit/samples/C2040/EK_251df20048757db6e75f.pad") (error "EdaKit: save padstack failed"))
    )
    (unless (axlDBCreatePin "EK_251df20048757db6e75f" 0.5999:-3.4249 (make_axlPinText ?number "48" ?offset 0:0 ?text (make_axlTextOrientation ?textBlock 1 ?rotation 0.0 ?justify "center")) 270.0000) (error "EdaKit: create pin failed"))
    (unless (axlDBCreatePadStack "EK_ad79043d7ccc6e2170e2" nil (list (make_axlPadStackPad ?layer "TOP" ?type 'REGULAR ?figure 'RECTANGLE ?figureSize 0.8500:0.2000) (make_axlPadStackPad ?layer "SOLDERMASK_TOP" ?type 'REGULAR ?figure 'RECTANGLE ?figureSize 0.8500:0.2000) (make_axlPadStackPad ?layer "PASTEMASK_TOP" ?type 'REGULAR ?figure 'RECTANGLE ?figureSize 0.8500:0.2000))) (error "EdaKit: create padstack failed"))
    (unless (isFile "E:/outputs/edakit/samples/C2040/EK_ad79043d7ccc6e2170e2.pad")
    (unless (axlPadstackToDisk "EK_ad79043d7ccc6e2170e2" "E:/outputs/edakit/samples/C2040/EK_ad79043d7ccc6e2170e2.pad") (error "EdaKit: save padstack failed"))
    )
    (unless (axlDBCreatePin "EK_ad79043d7ccc6e2170e2" 1.0000:-3.4249 (make_axlPinText ?number "47" ?offset 0:0 ?text (make_axlTextOrientation ?textBlock 1 ?rotation 0.0 ?justify "center")) 270.0000) (error "EdaKit: create pin failed"))
    (unless (axlDBCreatePadStack "EK_19fc86f9b2482d05da4e" nil (list (make_axlPadStackPad ?layer "TOP" ?type 'REGULAR ?figure 'RECTANGLE ?figureSize 0.8500:0.2000) (make_axlPadStackPad ?layer "SOLDERMASK_TOP" ?type 'REGULAR ?figure 'RECTANGLE ?figureSize 0.8500:0.2000) (make_axlPadStackPad ?layer "PASTEMASK_TOP" ?type 'REGULAR ?figure 'RECTANGLE ?figureSize 0.8500:0.2000))) (error "EdaKit: create padstack failed"))
    (unless (isFile "E:/outputs/edakit/samples/C2040/EK_19fc86f9b2482d05da4e.pad")
    (unless (axlPadstackToDisk "EK_19fc86f9b2482d05da4e" "E:/outputs/edakit/samples/C2040/EK_19fc86f9b2482d05da4e.pad") (error "EdaKit: save padstack failed"))
    )
    (unless (axlDBCreatePin "EK_19fc86f9b2482d05da4e" 1.4000:-3.4249 (make_axlPinText ?number "46" ?offset 0:0 ?text (make_axlTextOrientation ?textBlock 1 ?rotation 0.0 ?justify "center")) 270.0000) (error "EdaKit: create pin failed"))
    (unless (axlDBCreatePadStack "EK_f36dd6a12f795e30be0b" nil (list (make_axlPadStackPad ?layer "TOP" ?type 'REGULAR ?figure 'RECTANGLE ?figureSize 0.8500:0.2000) (make_axlPadStackPad ?layer "SOLDERMASK_TOP" ?type 'REGULAR ?figure 'RECTANGLE ?figureSize 0.8500:0.2000) (make_axlPadStackPad ?layer "PASTEMASK_TOP" ?type 'REGULAR ?figure 'RECTANGLE ?figureSize 0.8500:0.2000))) (error "EdaKit: create padstack failed"))
    (unless (isFile "E:/outputs/edakit/samples/C2040/EK_f36dd6a12f795e30be0b.pad")
    (unless (axlPadstackToDisk "EK_f36dd6a12f795e30be0b" "E:/outputs/edakit/samples/C2040/EK_f36dd6a12f795e30be0b.pad") (error "EdaKit: save padstack failed"))
    )
    (unless (axlDBCreatePin "EK_f36dd6a12f795e30be0b" 1.7998:-3.4249 (make_axlPinText ?number "45" ?offset 0:0 ?text (make_axlTextOrientation ?textBlock 1 ?rotation 0.0 ?justify "center")) 270.0000) (error "EdaKit: create pin failed"))
    (unless (axlDBCreatePadStack "EK_a9f0cb1414e554e55463" nil (list (make_axlPadStackPad ?layer "TOP" ?type 'REGULAR ?figure 'RECTANGLE ?figureSize 0.8500:0.2000) (make_axlPadStackPad ?layer "SOLDERMASK_TOP" ?type 'REGULAR ?figure 'RECTANGLE ?figureSize 0.8500:0.2000) (make_axlPadStackPad ?layer "PASTEMASK_TOP" ?type 'REGULAR ?figure 'RECTANGLE ?figureSize 0.8500:0.2000))) (error "EdaKit: create padstack failed"))
    (unless (isFile "E:/outputs/edakit/samples/C2040/EK_a9f0cb1414e554e55463.pad")
    (unless (axlPadstackToDisk "EK_a9f0cb1414e554e55463" "E:/outputs/edakit/samples/C2040/EK_a9f0cb1414e554e55463.pad") (error "EdaKit: save padstack failed"))
    )
    (unless (axlDBCreatePin "EK_a9f0cb1414e554e55463" 2.1999:-3.4249 (make_axlPinText ?number "44" ?offset 0:0 ?text (make_axlTextOrientation ?textBlock 1 ?rotation 0.0 ?justify "center")) 270.0000) (error "EdaKit: create pin failed"))
    (unless (axlDBCreatePadStack "EK_9e5389fa02a98dc7cec9" nil (list (make_axlPadStackPad ?layer "TOP" ?type 'REGULAR ?figure 'RECTANGLE ?figureSize 0.8500:0.2000) (make_axlPadStackPad ?layer "SOLDERMASK_TOP" ?type 'REGULAR ?figure 'RECTANGLE ?figureSize 0.8500:0.2000) (make_axlPadStackPad ?layer "PASTEMASK_TOP" ?type 'REGULAR ?figure 'RECTANGLE ?figureSize 0.8500:0.2000))) (error "EdaKit: create padstack failed"))
    (unless (isFile "E:/outputs/edakit/samples/C2040/EK_9e5389fa02a98dc7cec9.pad")
    (unless (axlPadstackToDisk "EK_9e5389fa02a98dc7cec9" "E:/outputs/edakit/samples/C2040/EK_9e5389fa02a98dc7cec9.pad") (error "EdaKit: save padstack failed"))
    )
    (unless (axlDBCreatePin "EK_9e5389fa02a98dc7cec9" 2.5999:-3.4249 (make_axlPinText ?number "43" ?offset 0:0 ?text (make_axlTextOrientation ?textBlock 1 ?rotation 0.0 ?justify "center")) 270.0000) (error "EdaKit: create pin failed"))
    (unless (axlDBCreatePadStack "EK_2fbc328ad185e66013aa" nil (list (make_axlPadStackPad ?layer "TOP" ?type 'REGULAR ?figure 'RECTANGLE ?figureSize 0.8500:0.2000) (make_axlPadStackPad ?layer "SOLDERMASK_TOP" ?type 'REGULAR ?figure 'RECTANGLE ?figureSize 0.8500:0.2000) (make_axlPadStackPad ?layer "PASTEMASK_TOP" ?type 'REGULAR ?figure 'RECTANGLE ?figureSize 0.8500:0.2000))) (error "EdaKit: create padstack failed"))
    (unless (isFile "E:/outputs/edakit/samples/C2040/EK_2fbc328ad185e66013aa.pad")
    (unless (axlPadstackToDisk "EK_2fbc328ad185e66013aa" "E:/outputs/edakit/samples/C2040/EK_2fbc328ad185e66013aa.pad") (error "EdaKit: save padstack failed"))
    )
    (unless (axlDBCreatePin "EK_2fbc328ad185e66013aa" 3.4249:-2.5999 (make_axlPinText ?number "42" ?offset 0:0 ?text (make_axlTextOrientation ?textBlock 1 ?rotation 0.0 ?justify "center")) 180.0000) (error "EdaKit: create pin failed"))
    (unless (axlDBCreatePadStack "EK_d9bbe05fa78fd7b0246d" nil (list (make_axlPadStackPad ?layer "TOP" ?type 'REGULAR ?figure 'RECTANGLE ?figureSize 0.8500:0.2000) (make_axlPadStackPad ?layer "SOLDERMASK_TOP" ?type 'REGULAR ?figure 'RECTANGLE ?figureSize 0.8500:0.2000) (make_axlPadStackPad ?layer "PASTEMASK_TOP" ?type 'REGULAR ?figure 'RECTANGLE ?figureSize 0.8500:0.2000))) (error "EdaKit: create padstack failed"))
    (unless (isFile "E:/outputs/edakit/samples/C2040/EK_d9bbe05fa78fd7b0246d.pad")
    (unless (axlPadstackToDisk "EK_d9bbe05fa78fd7b0246d" "E:/outputs/edakit/samples/C2040/EK_d9bbe05fa78fd7b0246d.pad") (error "EdaKit: save padstack failed"))
    )
    (unless (axlDBCreatePin "EK_d9bbe05fa78fd7b0246d" 3.4249:-2.1999 (make_axlPinText ?number "41" ?offset 0:0 ?text (make_axlTextOrientation ?textBlock 1 ?rotation 0.0 ?justify "center")) 180.0000) (error "EdaKit: create pin failed"))
    (unless (axlDBCreatePadStack "EK_f1b992d337db28e49e42" nil (list (make_axlPadStackPad ?layer "TOP" ?type 'REGULAR ?figure 'RECTANGLE ?figureSize 0.8500:0.2000) (make_axlPadStackPad ?layer "SOLDERMASK_TOP" ?type 'REGULAR ?figure 'RECTANGLE ?figureSize 0.8500:0.2000) (make_axlPadStackPad ?layer "PASTEMASK_TOP" ?type 'REGULAR ?figure 'RECTANGLE ?figureSize 0.8500:0.2000))) (error "EdaKit: create padstack failed"))
    (unless (isFile "E:/outputs/edakit/samples/C2040/EK_f1b992d337db28e49e42.pad")
    (unless (axlPadstackToDisk "EK_f1b992d337db28e49e42" "E:/outputs/edakit/samples/C2040/EK_f1b992d337db28e49e42.pad") (error "EdaKit: save padstack failed"))
    )
    (unless (axlDBCreatePin "EK_f1b992d337db28e49e42" 3.4249:-1.7998 (make_axlPinText ?number "40" ?offset 0:0 ?text (make_axlTextOrientation ?textBlock 1 ?rotation 0.0 ?justify "center")) 180.0000) (error "EdaKit: create pin failed"))
    (unless (axlDBCreatePadStack "EK_680f1f36c6860cf29de4" nil (list (make_axlPadStackPad ?layer "TOP" ?type 'REGULAR ?figure 'RECTANGLE ?figureSize 0.8500:0.2000) (make_axlPadStackPad ?layer "SOLDERMASK_TOP" ?type 'REGULAR ?figure 'RECTANGLE ?figureSize 0.8500:0.2000) (make_axlPadStackPad ?layer "PASTEMASK_TOP" ?type 'REGULAR ?figure 'RECTANGLE ?figureSize 0.8500:0.2000))) (error "EdaKit: create padstack failed"))
    (unless (isFile "E:/outputs/edakit/samples/C2040/EK_680f1f36c6860cf29de4.pad")
    (unless (axlPadstackToDisk "EK_680f1f36c6860cf29de4" "E:/outputs/edakit/samples/C2040/EK_680f1f36c6860cf29de4.pad") (error "EdaKit: save padstack failed"))
    )
    (unless (axlDBCreatePin "EK_680f1f36c6860cf29de4" 3.4249:-1.3998 (make_axlPinText ?number "39" ?offset 0:0 ?text (make_axlTextOrientation ?textBlock 1 ?rotation 0.0 ?justify "center")) 180.0000) (error "EdaKit: create pin failed"))
    (unless (axlDBCreatePadStack "EK_18f9e42fe0bbfcb5365b" nil (list (make_axlPadStackPad ?layer "TOP" ?type 'REGULAR ?figure 'RECTANGLE ?figureSize 0.8500:0.2000) (make_axlPadStackPad ?layer "SOLDERMASK_TOP" ?type 'REGULAR ?figure 'RECTANGLE ?figureSize 0.8500:0.2000) (make_axlPadStackPad ?layer "PASTEMASK_TOP" ?type 'REGULAR ?figure 'RECTANGLE ?figureSize 0.8500:0.2000))) (error "EdaKit: create padstack failed"))
    (unless (isFile "E:/outputs/edakit/samples/C2040/EK_18f9e42fe0bbfcb5365b.pad")
    (unless (axlPadstackToDisk "EK_18f9e42fe0bbfcb5365b" "E:/outputs/edakit/samples/C2040/EK_18f9e42fe0bbfcb5365b.pad") (error "EdaKit: save padstack failed"))
    )
    (unless (axlDBCreatePin "EK_18f9e42fe0bbfcb5365b" 3.4249:-1.0000 (make_axlPinText ?number "38" ?offset 0:0 ?text (make_axlTextOrientation ?textBlock 1 ?rotation 0.0 ?justify "center")) 180.0000) (error "EdaKit: create pin failed"))
    (unless (axlDBCreatePadStack "EK_3573be5d8677dcd3d8c7" nil (list (make_axlPadStackPad ?layer "TOP" ?type 'REGULAR ?figure 'RECTANGLE ?figureSize 0.8500:0.2000) (make_axlPadStackPad ?layer "SOLDERMASK_TOP" ?type 'REGULAR ?figure 'RECTANGLE ?figureSize 0.8500:0.2000) (make_axlPadStackPad ?layer "PASTEMASK_TOP" ?type 'REGULAR ?figure 'RECTANGLE ?figureSize 0.8500:0.2000))) (error "EdaKit: create padstack failed"))
    (unless (isFile "E:/outputs/edakit/samples/C2040/EK_3573be5d8677dcd3d8c7.pad")
    (unless (axlPadstackToDisk "EK_3573be5d8677dcd3d8c7" "E:/outputs/edakit/samples/C2040/EK_3573be5d8677dcd3d8c7.pad") (error "EdaKit: save padstack failed"))
    )
    (unless (axlDBCreatePin "EK_3573be5d8677dcd3d8c7" 3.4249:-0.5999 (make_axlPinText ?number "37" ?offset 0:0 ?text (make_axlTextOrientation ?textBlock 1 ?rotation 0.0 ?justify "center")) 180.0000) (error "EdaKit: create pin failed"))
    (unless (axlDBCreatePadStack "EK_e9ed121b116e26f4cd59" nil (list (make_axlPadStackPad ?layer "TOP" ?type 'REGULAR ?figure 'RECTANGLE ?figureSize 0.8500:0.2000) (make_axlPadStackPad ?layer "SOLDERMASK_TOP" ?type 'REGULAR ?figure 'RECTANGLE ?figureSize 0.8500:0.2000) (make_axlPadStackPad ?layer "PASTEMASK_TOP" ?type 'REGULAR ?figure 'RECTANGLE ?figureSize 0.8500:0.2000))) (error "EdaKit: create padstack failed"))
    (unless (isFile "E:/outputs/edakit/samples/C2040/EK_e9ed121b116e26f4cd59.pad")
    (unless (axlPadstackToDisk "EK_e9ed121b116e26f4cd59" "E:/outputs/edakit/samples/C2040/EK_e9ed121b116e26f4cd59.pad") (error "EdaKit: save padstack failed"))
    )
    (unless (axlDBCreatePin "EK_e9ed121b116e26f4cd59" 3.4249:-0.1999 (make_axlPinText ?number "36" ?offset 0:0 ?text (make_axlTextOrientation ?textBlock 1 ?rotation 0.0 ?justify "center")) 180.0000) (error "EdaKit: create pin failed"))
    (unless (axlDBCreatePadStack "EK_642358ef29a7519ebee9" nil (list (make_axlPadStackPad ?layer "TOP" ?type 'REGULAR ?figure 'RECTANGLE ?figureSize 0.8500:0.2000) (make_axlPadStackPad ?layer "SOLDERMASK_TOP" ?type 'REGULAR ?figure 'RECTANGLE ?figureSize 0.8500:0.2000) (make_axlPadStackPad ?layer "PASTEMASK_TOP" ?type 'REGULAR ?figure 'RECTANGLE ?figureSize 0.8500:0.2000))) (error "EdaKit: create padstack failed"))
    (unless (isFile "E:/outputs/edakit/samples/C2040/EK_642358ef29a7519ebee9.pad")
    (unless (axlPadstackToDisk "EK_642358ef29a7519ebee9" "E:/outputs/edakit/samples/C2040/EK_642358ef29a7519ebee9.pad") (error "EdaKit: save padstack failed"))
    )
    (unless (axlDBCreatePin "EK_642358ef29a7519ebee9" 3.4249:0.2002 (make_axlPinText ?number "35" ?offset 0:0 ?text (make_axlTextOrientation ?textBlock 1 ?rotation 0.0 ?justify "center")) 180.0000) (error "EdaKit: create pin failed"))
    (unless (axlDBCreatePadStack "EK_57c0d3bf237595d8ebc9" nil (list (make_axlPadStackPad ?layer "TOP" ?type 'REGULAR ?figure 'RECTANGLE ?figureSize 0.8500:0.2000) (make_axlPadStackPad ?layer "SOLDERMASK_TOP" ?type 'REGULAR ?figure 'RECTANGLE ?figureSize 0.8500:0.2000) (make_axlPadStackPad ?layer "PASTEMASK_TOP" ?type 'REGULAR ?figure 'RECTANGLE ?figureSize 0.8500:0.2000))) (error "EdaKit: create padstack failed"))
    (unless (isFile "E:/outputs/edakit/samples/C2040/EK_57c0d3bf237595d8ebc9.pad")
    (unless (axlPadstackToDisk "EK_57c0d3bf237595d8ebc9" "E:/outputs/edakit/samples/C2040/EK_57c0d3bf237595d8ebc9.pad") (error "EdaKit: save padstack failed"))
    )
    (unless (axlDBCreatePin "EK_57c0d3bf237595d8ebc9" 3.4249:0.6002 (make_axlPinText ?number "34" ?offset 0:0 ?text (make_axlTextOrientation ?textBlock 1 ?rotation 0.0 ?justify "center")) 180.0000) (error "EdaKit: create pin failed"))
    (unless (axlDBCreatePadStack "EK_e4b2cc40a1ef64b6fdfe" nil (list (make_axlPadStackPad ?layer "TOP" ?type 'REGULAR ?figure 'RECTANGLE ?figureSize 0.8500:0.2000) (make_axlPadStackPad ?layer "SOLDERMASK_TOP" ?type 'REGULAR ?figure 'RECTANGLE ?figureSize 0.8500:0.2000) (make_axlPadStackPad ?layer "PASTEMASK_TOP" ?type 'REGULAR ?figure 'RECTANGLE ?figureSize 0.8500:0.2000))) (error "EdaKit: create padstack failed"))
    (unless (isFile "E:/outputs/edakit/samples/C2040/EK_e4b2cc40a1ef64b6fdfe.pad")
    (unless (axlPadstackToDisk "EK_e4b2cc40a1ef64b6fdfe" "E:/outputs/edakit/samples/C2040/EK_e4b2cc40a1ef64b6fdfe.pad") (error "EdaKit: save padstack failed"))
    )
    (unless (axlDBCreatePin "EK_e4b2cc40a1ef64b6fdfe" 3.4249:1.0000 (make_axlPinText ?number "33" ?offset 0:0 ?text (make_axlTextOrientation ?textBlock 1 ?rotation 0.0 ?justify "center")) 180.0000) (error "EdaKit: create pin failed"))
    (unless (axlDBCreatePadStack "EK_a84badd55bdb37830168" nil (list (make_axlPadStackPad ?layer "TOP" ?type 'REGULAR ?figure 'RECTANGLE ?figureSize 0.8500:0.2000) (make_axlPadStackPad ?layer "SOLDERMASK_TOP" ?type 'REGULAR ?figure 'RECTANGLE ?figureSize 0.8500:0.2000) (make_axlPadStackPad ?layer "PASTEMASK_TOP" ?type 'REGULAR ?figure 'RECTANGLE ?figureSize 0.8500:0.2000))) (error "EdaKit: create padstack failed"))
    (unless (isFile "E:/outputs/edakit/samples/C2040/EK_a84badd55bdb37830168.pad")
    (unless (axlPadstackToDisk "EK_a84badd55bdb37830168" "E:/outputs/edakit/samples/C2040/EK_a84badd55bdb37830168.pad") (error "EdaKit: save padstack failed"))
    )
    (unless (axlDBCreatePin "EK_a84badd55bdb37830168" 3.4249:1.4000 (make_axlPinText ?number "32" ?offset 0:0 ?text (make_axlTextOrientation ?textBlock 1 ?rotation 0.0 ?justify "center")) 180.0000) (error "EdaKit: create pin failed"))
    (unless (axlDBCreatePadStack "EK_e33082bbe303a9821c4a" nil (list (make_axlPadStackPad ?layer "TOP" ?type 'REGULAR ?figure 'RECTANGLE ?figureSize 0.8500:0.2000) (make_axlPadStackPad ?layer "SOLDERMASK_TOP" ?type 'REGULAR ?figure 'RECTANGLE ?figureSize 0.8500:0.2000) (make_axlPadStackPad ?layer "PASTEMASK_TOP" ?type 'REGULAR ?figure 'RECTANGLE ?figureSize 0.8500:0.2000))) (error "EdaKit: create padstack failed"))
    (unless (isFile "E:/outputs/edakit/samples/C2040/EK_e33082bbe303a9821c4a.pad")
    (unless (axlPadstackToDisk "EK_e33082bbe303a9821c4a" "E:/outputs/edakit/samples/C2040/EK_e33082bbe303a9821c4a.pad") (error "EdaKit: save padstack failed"))
    )
    (unless (axlDBCreatePin "EK_e33082bbe303a9821c4a" 3.4249:1.8001 (make_axlPinText ?number "31" ?offset 0:0 ?text (make_axlTextOrientation ?textBlock 1 ?rotation 0.0 ?justify "center")) 180.0000) (error "EdaKit: create pin failed"))
    (unless (axlDBCreatePadStack "EK_1350e95b5b48a9819a92" nil (list (make_axlPadStackPad ?layer "TOP" ?type 'REGULAR ?figure 'RECTANGLE ?figureSize 0.8500:0.2000) (make_axlPadStackPad ?layer "SOLDERMASK_TOP" ?type 'REGULAR ?figure 'RECTANGLE ?figureSize 0.8500:0.2000) (make_axlPadStackPad ?layer "PASTEMASK_TOP" ?type 'REGULAR ?figure 'RECTANGLE ?figureSize 0.8500:0.2000))) (error "EdaKit: create padstack failed"))
    (unless (isFile "E:/outputs/edakit/samples/C2040/EK_1350e95b5b48a9819a92.pad")
    (unless (axlPadstackToDisk "EK_1350e95b5b48a9819a92" "E:/outputs/edakit/samples/C2040/EK_1350e95b5b48a9819a92.pad") (error "EdaKit: save padstack failed"))
    )
    (unless (axlDBCreatePin "EK_1350e95b5b48a9819a92" 3.4249:2.2001 (make_axlPinText ?number "30" ?offset 0:0 ?text (make_axlTextOrientation ?textBlock 1 ?rotation 0.0 ?justify "center")) 180.0000) (error "EdaKit: create pin failed"))
    (unless (axlDBCreatePadStack "EK_b5bbeeb5f60d45046cbd" nil (list (make_axlPadStackPad ?layer "TOP" ?type 'REGULAR ?figure 'RECTANGLE ?figureSize 0.8500:0.2000) (make_axlPadStackPad ?layer "SOLDERMASK_TOP" ?type 'REGULAR ?figure 'RECTANGLE ?figureSize 0.8500:0.2000) (make_axlPadStackPad ?layer "PASTEMASK_TOP" ?type 'REGULAR ?figure 'RECTANGLE ?figureSize 0.8500:0.2000))) (error "EdaKit: create padstack failed"))
    (unless (isFile "E:/outputs/edakit/samples/C2040/EK_b5bbeeb5f60d45046cbd.pad")
    (unless (axlPadstackToDisk "EK_b5bbeeb5f60d45046cbd" "E:/outputs/edakit/samples/C2040/EK_b5bbeeb5f60d45046cbd.pad") (error "EdaKit: save padstack failed"))
    )
    (unless (axlDBCreatePin "EK_b5bbeeb5f60d45046cbd" 3.4249:2.6002 (make_axlPinText ?number "29" ?offset 0:0 ?text (make_axlTextOrientation ?textBlock 1 ?rotation 0.0 ?justify "center")) 180.0000) (error "EdaKit: create pin failed"))
    (unless (axlDBCreatePadStack "EK_fe495f8d5c2ba7c5e93e" nil (list (make_axlPadStackPad ?layer "TOP" ?type 'REGULAR ?figure 'RECTANGLE ?figureSize 0.8500:0.2000) (make_axlPadStackPad ?layer "SOLDERMASK_TOP" ?type 'REGULAR ?figure 'RECTANGLE ?figureSize 0.8500:0.2000) (make_axlPadStackPad ?layer "PASTEMASK_TOP" ?type 'REGULAR ?figure 'RECTANGLE ?figureSize 0.8500:0.2000))) (error "EdaKit: create padstack failed"))
    (unless (isFile "E:/outputs/edakit/samples/C2040/EK_fe495f8d5c2ba7c5e93e.pad")
    (unless (axlPadstackToDisk "EK_fe495f8d5c2ba7c5e93e" "E:/outputs/edakit/samples/C2040/EK_fe495f8d5c2ba7c5e93e.pad") (error "EdaKit: save padstack failed"))
    )
    (unless (axlDBCreatePin "EK_fe495f8d5c2ba7c5e93e" 2.5999:3.4252 (make_axlPinText ?number "28" ?offset 0:0 ?text (make_axlTextOrientation ?textBlock 1 ?rotation 0.0 ?justify "center")) 90.0000) (error "EdaKit: create pin failed"))
    (unless (axlDBCreatePadStack "EK_8ecc1c739441402467bc" nil (list (make_axlPadStackPad ?layer "TOP" ?type 'REGULAR ?figure 'RECTANGLE ?figureSize 0.8500:0.2000) (make_axlPadStackPad ?layer "SOLDERMASK_TOP" ?type 'REGULAR ?figure 'RECTANGLE ?figureSize 0.8500:0.2000) (make_axlPadStackPad ?layer "PASTEMASK_TOP" ?type 'REGULAR ?figure 'RECTANGLE ?figureSize 0.8500:0.2000))) (error "EdaKit: create padstack failed"))
    (unless (isFile "E:/outputs/edakit/samples/C2040/EK_8ecc1c739441402467bc.pad")
    (unless (axlPadstackToDisk "EK_8ecc1c739441402467bc" "E:/outputs/edakit/samples/C2040/EK_8ecc1c739441402467bc.pad") (error "EdaKit: save padstack failed"))
    )
    (unless (axlDBCreatePin "EK_8ecc1c739441402467bc" 2.1999:3.4252 (make_axlPinText ?number "27" ?offset 0:0 ?text (make_axlTextOrientation ?textBlock 1 ?rotation 0.0 ?justify "center")) 90.0000) (error "EdaKit: create pin failed"))
    (unless (axlDBCreatePadStack "EK_e6ffe95cf49e8d4199c2" nil (list (make_axlPadStackPad ?layer "TOP" ?type 'REGULAR ?figure 'RECTANGLE ?figureSize 0.8500:0.2000) (make_axlPadStackPad ?layer "SOLDERMASK_TOP" ?type 'REGULAR ?figure 'RECTANGLE ?figureSize 0.8500:0.2000) (make_axlPadStackPad ?layer "PASTEMASK_TOP" ?type 'REGULAR ?figure 'RECTANGLE ?figureSize 0.8500:0.2000))) (error "EdaKit: create padstack failed"))
    (unless (isFile "E:/outputs/edakit/samples/C2040/EK_e6ffe95cf49e8d4199c2.pad")
    (unless (axlPadstackToDisk "EK_e6ffe95cf49e8d4199c2" "E:/outputs/edakit/samples/C2040/EK_e6ffe95cf49e8d4199c2.pad") (error "EdaKit: save padstack failed"))
    )
    (unless (axlDBCreatePin "EK_e6ffe95cf49e8d4199c2" 1.7998:3.4252 (make_axlPinText ?number "26" ?offset 0:0 ?text (make_axlTextOrientation ?textBlock 1 ?rotation 0.0 ?justify "center")) 90.0000) (error "EdaKit: create pin failed"))
    (unless (axlDBCreatePadStack "EK_17fbe511577f2d3ded12" nil (list (make_axlPadStackPad ?layer "TOP" ?type 'REGULAR ?figure 'RECTANGLE ?figureSize 0.8500:0.2000) (make_axlPadStackPad ?layer "SOLDERMASK_TOP" ?type 'REGULAR ?figure 'RECTANGLE ?figureSize 0.8500:0.2000) (make_axlPadStackPad ?layer "PASTEMASK_TOP" ?type 'REGULAR ?figure 'RECTANGLE ?figureSize 0.8500:0.2000))) (error "EdaKit: create padstack failed"))
    (unless (isFile "E:/outputs/edakit/samples/C2040/EK_17fbe511577f2d3ded12.pad")
    (unless (axlPadstackToDisk "EK_17fbe511577f2d3ded12" "E:/outputs/edakit/samples/C2040/EK_17fbe511577f2d3ded12.pad") (error "EdaKit: save padstack failed"))
    )
    (unless (axlDBCreatePin "EK_17fbe511577f2d3ded12" 1.4000:3.4252 (make_axlPinText ?number "25" ?offset 0:0 ?text (make_axlTextOrientation ?textBlock 1 ?rotation 0.0 ?justify "center")) 90.0000) (error "EdaKit: create pin failed"))
    (unless (axlDBCreatePadStack "EK_78bcfbbb6b59a7522880" nil (list (make_axlPadStackPad ?layer "TOP" ?type 'REGULAR ?figure 'RECTANGLE ?figureSize 0.8500:0.2000) (make_axlPadStackPad ?layer "SOLDERMASK_TOP" ?type 'REGULAR ?figure 'RECTANGLE ?figureSize 0.8500:0.2000) (make_axlPadStackPad ?layer "PASTEMASK_TOP" ?type 'REGULAR ?figure 'RECTANGLE ?figureSize 0.8500:0.2000))) (error "EdaKit: create padstack failed"))
    (unless (isFile "E:/outputs/edakit/samples/C2040/EK_78bcfbbb6b59a7522880.pad")
    (unless (axlPadstackToDisk "EK_78bcfbbb6b59a7522880" "E:/outputs/edakit/samples/C2040/EK_78bcfbbb6b59a7522880.pad") (error "EdaKit: save padstack failed"))
    )
    (unless (axlDBCreatePin "EK_78bcfbbb6b59a7522880" 1.0000:3.4252 (make_axlPinText ?number "24" ?offset 0:0 ?text (make_axlTextOrientation ?textBlock 1 ?rotation 0.0 ?justify "center")) 90.0000) (error "EdaKit: create pin failed"))
    (unless (axlDBCreatePadStack "EK_75e973ea5f9a6a121ee7" nil (list (make_axlPadStackPad ?layer "TOP" ?type 'REGULAR ?figure 'RECTANGLE ?figureSize 0.8500:0.2000) (make_axlPadStackPad ?layer "SOLDERMASK_TOP" ?type 'REGULAR ?figure 'RECTANGLE ?figureSize 0.8500:0.2000) (make_axlPadStackPad ?layer "PASTEMASK_TOP" ?type 'REGULAR ?figure 'RECTANGLE ?figureSize 0.8500:0.2000))) (error "EdaKit: create padstack failed"))
    (unless (isFile "E:/outputs/edakit/samples/C2040/EK_75e973ea5f9a6a121ee7.pad")
    (unless (axlPadstackToDisk "EK_75e973ea5f9a6a121ee7" "E:/outputs/edakit/samples/C2040/EK_75e973ea5f9a6a121ee7.pad") (error "EdaKit: save padstack failed"))
    )
    (unless (axlDBCreatePin "EK_75e973ea5f9a6a121ee7" 0.5999:3.4252 (make_axlPinText ?number "23" ?offset 0:0 ?text (make_axlTextOrientation ?textBlock 1 ?rotation 0.0 ?justify "center")) 90.0000) (error "EdaKit: create pin failed"))
    (unless (axlDBCreatePadStack "EK_d4a218430a6fb57a6083" nil (list (make_axlPadStackPad ?layer "TOP" ?type 'REGULAR ?figure 'RECTANGLE ?figureSize 0.8500:0.2000) (make_axlPadStackPad ?layer "SOLDERMASK_TOP" ?type 'REGULAR ?figure 'RECTANGLE ?figureSize 0.8500:0.2000) (make_axlPadStackPad ?layer "PASTEMASK_TOP" ?type 'REGULAR ?figure 'RECTANGLE ?figureSize 0.8500:0.2000))) (error "EdaKit: create padstack failed"))
    (unless (isFile "E:/outputs/edakit/samples/C2040/EK_d4a218430a6fb57a6083.pad")
    (unless (axlPadstackToDisk "EK_d4a218430a6fb57a6083" "E:/outputs/edakit/samples/C2040/EK_d4a218430a6fb57a6083.pad") (error "EdaKit: save padstack failed"))
    )
    (unless (axlDBCreatePin "EK_d4a218430a6fb57a6083" 0.1999:3.4252 (make_axlPinText ?number "22" ?offset 0:0 ?text (make_axlTextOrientation ?textBlock 1 ?rotation 0.0 ?justify "center")) 90.0000) (error "EdaKit: create pin failed"))
    (unless (axlDBCreatePadStack "EK_8c007adbbbc7f6dead05" nil (list (make_axlPadStackPad ?layer "TOP" ?type 'REGULAR ?figure 'RECTANGLE ?figureSize 0.8500:0.2000) (make_axlPadStackPad ?layer "SOLDERMASK_TOP" ?type 'REGULAR ?figure 'RECTANGLE ?figureSize 0.8500:0.2000) (make_axlPadStackPad ?layer "PASTEMASK_TOP" ?type 'REGULAR ?figure 'RECTANGLE ?figureSize 0.8500:0.2000))) (error "EdaKit: create padstack failed"))
    (unless (isFile "E:/outputs/edakit/samples/C2040/EK_8c007adbbbc7f6dead05.pad")
    (unless (axlPadstackToDisk "EK_8c007adbbbc7f6dead05" "E:/outputs/edakit/samples/C2040/EK_8c007adbbbc7f6dead05.pad") (error "EdaKit: save padstack failed"))
    )
    (unless (axlDBCreatePin "EK_8c007adbbbc7f6dead05" -0.2002:3.4252 (make_axlPinText ?number "21" ?offset 0:0 ?text (make_axlTextOrientation ?textBlock 1 ?rotation 0.0 ?justify "center")) 90.0000) (error "EdaKit: create pin failed"))
    (unless (axlDBCreatePadStack "EK_ac91d259b07c921b14b9" nil (list (make_axlPadStackPad ?layer "TOP" ?type 'REGULAR ?figure 'RECTANGLE ?figureSize 0.8500:0.2000) (make_axlPadStackPad ?layer "SOLDERMASK_TOP" ?type 'REGULAR ?figure 'RECTANGLE ?figureSize 0.8500:0.2000) (make_axlPadStackPad ?layer "PASTEMASK_TOP" ?type 'REGULAR ?figure 'RECTANGLE ?figureSize 0.8500:0.2000))) (error "EdaKit: create padstack failed"))
    (unless (isFile "E:/outputs/edakit/samples/C2040/EK_ac91d259b07c921b14b9.pad")
    (unless (axlPadstackToDisk "EK_ac91d259b07c921b14b9" "E:/outputs/edakit/samples/C2040/EK_ac91d259b07c921b14b9.pad") (error "EdaKit: save padstack failed"))
    )
    (unless (axlDBCreatePin "EK_ac91d259b07c921b14b9" -0.5999:3.4252 (make_axlPinText ?number "20" ?offset 0:0 ?text (make_axlTextOrientation ?textBlock 1 ?rotation 0.0 ?justify "center")) 90.0000) (error "EdaKit: create pin failed"))
    (unless (axlDBCreatePadStack "EK_10b0463ec70f45f75bb9" nil (list (make_axlPadStackPad ?layer "TOP" ?type 'REGULAR ?figure 'RECTANGLE ?figureSize 0.8500:0.2000) (make_axlPadStackPad ?layer "SOLDERMASK_TOP" ?type 'REGULAR ?figure 'RECTANGLE ?figureSize 0.8500:0.2000) (make_axlPadStackPad ?layer "PASTEMASK_TOP" ?type 'REGULAR ?figure 'RECTANGLE ?figureSize 0.8500:0.2000))) (error "EdaKit: create padstack failed"))
    (unless (isFile "E:/outputs/edakit/samples/C2040/EK_10b0463ec70f45f75bb9.pad")
    (unless (axlPadstackToDisk "EK_10b0463ec70f45f75bb9" "E:/outputs/edakit/samples/C2040/EK_10b0463ec70f45f75bb9.pad") (error "EdaKit: save padstack failed"))
    )
    (unless (axlDBCreatePin "EK_10b0463ec70f45f75bb9" -1.0000:3.4252 (make_axlPinText ?number "19" ?offset 0:0 ?text (make_axlTextOrientation ?textBlock 1 ?rotation 0.0 ?justify "center")) 90.0000) (error "EdaKit: create pin failed"))
    (unless (axlDBCreatePadStack "EK_7d6bbbaba05a33dada74" nil (list (make_axlPadStackPad ?layer "TOP" ?type 'REGULAR ?figure 'RECTANGLE ?figureSize 0.8500:0.2000) (make_axlPadStackPad ?layer "SOLDERMASK_TOP" ?type 'REGULAR ?figure 'RECTANGLE ?figureSize 0.8500:0.2000) (make_axlPadStackPad ?layer "PASTEMASK_TOP" ?type 'REGULAR ?figure 'RECTANGLE ?figureSize 0.8500:0.2000))) (error "EdaKit: create padstack failed"))
    (unless (isFile "E:/outputs/edakit/samples/C2040/EK_7d6bbbaba05a33dada74.pad")
    (unless (axlPadstackToDisk "EK_7d6bbbaba05a33dada74" "E:/outputs/edakit/samples/C2040/EK_7d6bbbaba05a33dada74.pad") (error "EdaKit: save padstack failed"))
    )
    (unless (axlDBCreatePin "EK_7d6bbbaba05a33dada74" -1.4000:3.4252 (make_axlPinText ?number "18" ?offset 0:0 ?text (make_axlTextOrientation ?textBlock 1 ?rotation 0.0 ?justify "center")) 90.0000) (error "EdaKit: create pin failed"))
    (unless (axlDBCreatePadStack "EK_55a368a61275a016d122" nil (list (make_axlPadStackPad ?layer "TOP" ?type 'REGULAR ?figure 'RECTANGLE ?figureSize 0.8500:0.2000) (make_axlPadStackPad ?layer "SOLDERMASK_TOP" ?type 'REGULAR ?figure 'RECTANGLE ?figureSize 0.8500:0.2000) (make_axlPadStackPad ?layer "PASTEMASK_TOP" ?type 'REGULAR ?figure 'RECTANGLE ?figureSize 0.8500:0.2000))) (error "EdaKit: create padstack failed"))
    (unless (isFile "E:/outputs/edakit/samples/C2040/EK_55a368a61275a016d122.pad")
    (unless (axlPadstackToDisk "EK_55a368a61275a016d122" "E:/outputs/edakit/samples/C2040/EK_55a368a61275a016d122.pad") (error "EdaKit: save padstack failed"))
    )
    (unless (axlDBCreatePin "EK_55a368a61275a016d122" -1.8001:3.4252 (make_axlPinText ?number "17" ?offset 0:0 ?text (make_axlTextOrientation ?textBlock 1 ?rotation 0.0 ?justify "center")) 90.0000) (error "EdaKit: create pin failed"))
    (unless (axlDBCreatePadStack "EK_56bfd2944f48f94407e1" nil (list (make_axlPadStackPad ?layer "TOP" ?type 'REGULAR ?figure 'RECTANGLE ?figureSize 0.8500:0.2000) (make_axlPadStackPad ?layer "SOLDERMASK_TOP" ?type 'REGULAR ?figure 'RECTANGLE ?figureSize 0.8500:0.2000) (make_axlPadStackPad ?layer "PASTEMASK_TOP" ?type 'REGULAR ?figure 'RECTANGLE ?figureSize 0.8500:0.2000))) (error "EdaKit: create padstack failed"))
    (unless (isFile "E:/outputs/edakit/samples/C2040/EK_56bfd2944f48f94407e1.pad")
    (unless (axlPadstackToDisk "EK_56bfd2944f48f94407e1" "E:/outputs/edakit/samples/C2040/EK_56bfd2944f48f94407e1.pad") (error "EdaKit: save padstack failed"))
    )
    (unless (axlDBCreatePin "EK_56bfd2944f48f94407e1" -2.2001:3.4252 (make_axlPinText ?number "16" ?offset 0:0 ?text (make_axlTextOrientation ?textBlock 1 ?rotation 0.0 ?justify "center")) 90.0000) (error "EdaKit: create pin failed"))
    (unless (axlDBCreatePadStack "EK_372bfb595a369af348a4" nil (list (make_axlPadStackPad ?layer "TOP" ?type 'REGULAR ?figure 'RECTANGLE ?figureSize 0.8500:0.2000) (make_axlPadStackPad ?layer "SOLDERMASK_TOP" ?type 'REGULAR ?figure 'RECTANGLE ?figureSize 0.8500:0.2000) (make_axlPadStackPad ?layer "PASTEMASK_TOP" ?type 'REGULAR ?figure 'RECTANGLE ?figureSize 0.8500:0.2000))) (error "EdaKit: create padstack failed"))
    (unless (isFile "E:/outputs/edakit/samples/C2040/EK_372bfb595a369af348a4.pad")
    (unless (axlPadstackToDisk "EK_372bfb595a369af348a4" "E:/outputs/edakit/samples/C2040/EK_372bfb595a369af348a4.pad") (error "EdaKit: save padstack failed"))
    )
    (unless (axlDBCreatePin "EK_372bfb595a369af348a4" -2.5999:3.4252 (make_axlPinText ?number "15" ?offset 0:0 ?text (make_axlTextOrientation ?textBlock 1 ?rotation 0.0 ?justify "center")) 90.0000) (error "EdaKit: create pin failed"))
    (unless (axlDBCreatePadStack "EK_3c3612cbdea0d086b3bb" nil (list (make_axlPadStackPad ?layer "TOP" ?type 'REGULAR ?figure 'RECTANGLE ?figureSize 0.8500:0.2000) (make_axlPadStackPad ?layer "SOLDERMASK_TOP" ?type 'REGULAR ?figure 'RECTANGLE ?figureSize 0.8500:0.2000) (make_axlPadStackPad ?layer "PASTEMASK_TOP" ?type 'REGULAR ?figure 'RECTANGLE ?figureSize 0.8500:0.2000))) (error "EdaKit: create padstack failed"))
    (unless (isFile "E:/outputs/edakit/samples/C2040/EK_3c3612cbdea0d086b3bb.pad")
    (unless (axlPadstackToDisk "EK_3c3612cbdea0d086b3bb" "E:/outputs/edakit/samples/C2040/EK_3c3612cbdea0d086b3bb.pad") (error "EdaKit: save padstack failed"))
    )
    (unless (axlDBCreatePin "EK_3c3612cbdea0d086b3bb" -3.4249:2.6002 (make_axlPinText ?number "14" ?offset 0:0 ?text (make_axlTextOrientation ?textBlock 1 ?rotation 0.0 ?justify "center")) 0.0000) (error "EdaKit: create pin failed"))
    (unless (axlDBCreatePadStack "EK_444fc0382bd0fa27e6cd" nil (list (make_axlPadStackPad ?layer "TOP" ?type 'REGULAR ?figure 'RECTANGLE ?figureSize 0.8500:0.2000) (make_axlPadStackPad ?layer "SOLDERMASK_TOP" ?type 'REGULAR ?figure 'RECTANGLE ?figureSize 0.8500:0.2000) (make_axlPadStackPad ?layer "PASTEMASK_TOP" ?type 'REGULAR ?figure 'RECTANGLE ?figureSize 0.8500:0.2000))) (error "EdaKit: create padstack failed"))
    (unless (isFile "E:/outputs/edakit/samples/C2040/EK_444fc0382bd0fa27e6cd.pad")
    (unless (axlPadstackToDisk "EK_444fc0382bd0fa27e6cd" "E:/outputs/edakit/samples/C2040/EK_444fc0382bd0fa27e6cd.pad") (error "EdaKit: save padstack failed"))
    )
    (unless (axlDBCreatePin "EK_444fc0382bd0fa27e6cd" -3.4249:2.2001 (make_axlPinText ?number "13" ?offset 0:0 ?text (make_axlTextOrientation ?textBlock 1 ?rotation 0.0 ?justify "center")) 0.0000) (error "EdaKit: create pin failed"))
    (unless (axlDBCreatePadStack "EK_0ad3bc568eec56924ca6" nil (list (make_axlPadStackPad ?layer "TOP" ?type 'REGULAR ?figure 'RECTANGLE ?figureSize 0.8500:0.2000) (make_axlPadStackPad ?layer "SOLDERMASK_TOP" ?type 'REGULAR ?figure 'RECTANGLE ?figureSize 0.8500:0.2000) (make_axlPadStackPad ?layer "PASTEMASK_TOP" ?type 'REGULAR ?figure 'RECTANGLE ?figureSize 0.8500:0.2000))) (error "EdaKit: create padstack failed"))
    (unless (isFile "E:/outputs/edakit/samples/C2040/EK_0ad3bc568eec56924ca6.pad")
    (unless (axlPadstackToDisk "EK_0ad3bc568eec56924ca6" "E:/outputs/edakit/samples/C2040/EK_0ad3bc568eec56924ca6.pad") (error "EdaKit: save padstack failed"))
    )
    (unless (axlDBCreatePin "EK_0ad3bc568eec56924ca6" -3.4249:1.8001 (make_axlPinText ?number "12" ?offset 0:0 ?text (make_axlTextOrientation ?textBlock 1 ?rotation 0.0 ?justify "center")) 0.0000) (error "EdaKit: create pin failed"))
    (unless (axlDBCreatePadStack "EK_399f7d7689a57d0cee92" nil (list (make_axlPadStackPad ?layer "TOP" ?type 'REGULAR ?figure 'RECTANGLE ?figureSize 0.8500:0.2000) (make_axlPadStackPad ?layer "SOLDERMASK_TOP" ?type 'REGULAR ?figure 'RECTANGLE ?figureSize 0.8500:0.2000) (make_axlPadStackPad ?layer "PASTEMASK_TOP" ?type 'REGULAR ?figure 'RECTANGLE ?figureSize 0.8500:0.2000))) (error "EdaKit: create padstack failed"))
    (unless (isFile "E:/outputs/edakit/samples/C2040/EK_399f7d7689a57d0cee92.pad")
    (unless (axlPadstackToDisk "EK_399f7d7689a57d0cee92" "E:/outputs/edakit/samples/C2040/EK_399f7d7689a57d0cee92.pad") (error "EdaKit: save padstack failed"))
    )
    (unless (axlDBCreatePin "EK_399f7d7689a57d0cee92" -3.4249:1.4000 (make_axlPinText ?number "11" ?offset 0:0 ?text (make_axlTextOrientation ?textBlock 1 ?rotation 0.0 ?justify "center")) 0.0000) (error "EdaKit: create pin failed"))
    (unless (axlDBCreatePadStack "EK_81e6fc1aa79539aa0946" nil (list (make_axlPadStackPad ?layer "TOP" ?type 'REGULAR ?figure 'RECTANGLE ?figureSize 0.8500:0.2000) (make_axlPadStackPad ?layer "SOLDERMASK_TOP" ?type 'REGULAR ?figure 'RECTANGLE ?figureSize 0.8500:0.2000) (make_axlPadStackPad ?layer "PASTEMASK_TOP" ?type 'REGULAR ?figure 'RECTANGLE ?figureSize 0.8500:0.2000))) (error "EdaKit: create padstack failed"))
    (unless (isFile "E:/outputs/edakit/samples/C2040/EK_81e6fc1aa79539aa0946.pad")
    (unless (axlPadstackToDisk "EK_81e6fc1aa79539aa0946" "E:/outputs/edakit/samples/C2040/EK_81e6fc1aa79539aa0946.pad") (error "EdaKit: save padstack failed"))
    )
    (unless (axlDBCreatePin "EK_81e6fc1aa79539aa0946" -3.4249:1.0000 (make_axlPinText ?number "10" ?offset 0:0 ?text (make_axlTextOrientation ?textBlock 1 ?rotation 0.0 ?justify "center")) 0.0000) (error "EdaKit: create pin failed"))
    (unless (axlDBCreatePadStack "EK_98f7e0be8ed30345d163" nil (list (make_axlPadStackPad ?layer "TOP" ?type 'REGULAR ?figure 'RECTANGLE ?figureSize 0.8500:0.2000) (make_axlPadStackPad ?layer "SOLDERMASK_TOP" ?type 'REGULAR ?figure 'RECTANGLE ?figureSize 0.8500:0.2000) (make_axlPadStackPad ?layer "PASTEMASK_TOP" ?type 'REGULAR ?figure 'RECTANGLE ?figureSize 0.8500:0.2000))) (error "EdaKit: create padstack failed"))
    (unless (isFile "E:/outputs/edakit/samples/C2040/EK_98f7e0be8ed30345d163.pad")
    (unless (axlPadstackToDisk "EK_98f7e0be8ed30345d163" "E:/outputs/edakit/samples/C2040/EK_98f7e0be8ed30345d163.pad") (error "EdaKit: save padstack failed"))
    )
    (unless (axlDBCreatePin "EK_98f7e0be8ed30345d163" -3.4249:0.6002 (make_axlPinText ?number "9" ?offset 0:0 ?text (make_axlTextOrientation ?textBlock 1 ?rotation 0.0 ?justify "center")) 0.0000) (error "EdaKit: create pin failed"))
    (unless (axlDBCreatePadStack "EK_0c1d6ee4946da7cd2062" nil (list (make_axlPadStackPad ?layer "TOP" ?type 'REGULAR ?figure 'RECTANGLE ?figureSize 0.8500:0.2000) (make_axlPadStackPad ?layer "SOLDERMASK_TOP" ?type 'REGULAR ?figure 'RECTANGLE ?figureSize 0.8500:0.2000) (make_axlPadStackPad ?layer "PASTEMASK_TOP" ?type 'REGULAR ?figure 'RECTANGLE ?figureSize 0.8500:0.2000))) (error "EdaKit: create padstack failed"))
    (unless (isFile "E:/outputs/edakit/samples/C2040/EK_0c1d6ee4946da7cd2062.pad")
    (unless (axlPadstackToDisk "EK_0c1d6ee4946da7cd2062" "E:/outputs/edakit/samples/C2040/EK_0c1d6ee4946da7cd2062.pad") (error "EdaKit: save padstack failed"))
    )
    (unless (axlDBCreatePin "EK_0c1d6ee4946da7cd2062" -3.4249:0.2002 (make_axlPinText ?number "8" ?offset 0:0 ?text (make_axlTextOrientation ?textBlock 1 ?rotation 0.0 ?justify "center")) 0.0000) (error "EdaKit: create pin failed"))
    (unless (axlDBCreatePadStack "EK_ae068474425e4aa686eb" nil (list (make_axlPadStackPad ?layer "TOP" ?type 'REGULAR ?figure 'RECTANGLE ?figureSize 0.8500:0.2000) (make_axlPadStackPad ?layer "SOLDERMASK_TOP" ?type 'REGULAR ?figure 'RECTANGLE ?figureSize 0.8500:0.2000) (make_axlPadStackPad ?layer "PASTEMASK_TOP" ?type 'REGULAR ?figure 'RECTANGLE ?figureSize 0.8500:0.2000))) (error "EdaKit: create padstack failed"))
    (unless (isFile "E:/outputs/edakit/samples/C2040/EK_ae068474425e4aa686eb.pad")
    (unless (axlPadstackToDisk "EK_ae068474425e4aa686eb" "E:/outputs/edakit/samples/C2040/EK_ae068474425e4aa686eb.pad") (error "EdaKit: save padstack failed"))
    )
    (unless (axlDBCreatePin "EK_ae068474425e4aa686eb" -3.4249:-0.1999 (make_axlPinText ?number "7" ?offset 0:0 ?text (make_axlTextOrientation ?textBlock 1 ?rotation 0.0 ?justify "center")) 0.0000) (error "EdaKit: create pin failed"))
    (unless (axlDBCreatePadStack "EK_075545b760e30d2053f6" nil (list (make_axlPadStackPad ?layer "TOP" ?type 'REGULAR ?figure 'RECTANGLE ?figureSize 0.8500:0.2000) (make_axlPadStackPad ?layer "SOLDERMASK_TOP" ?type 'REGULAR ?figure 'RECTANGLE ?figureSize 0.8500:0.2000) (make_axlPadStackPad ?layer "PASTEMASK_TOP" ?type 'REGULAR ?figure 'RECTANGLE ?figureSize 0.8500:0.2000))) (error "EdaKit: create padstack failed"))
    (unless (isFile "E:/outputs/edakit/samples/C2040/EK_075545b760e30d2053f6.pad")
    (unless (axlPadstackToDisk "EK_075545b760e30d2053f6" "E:/outputs/edakit/samples/C2040/EK_075545b760e30d2053f6.pad") (error "EdaKit: save padstack failed"))
    )
    (unless (axlDBCreatePin "EK_075545b760e30d2053f6" -3.4249:-0.5999 (make_axlPinText ?number "6" ?offset 0:0 ?text (make_axlTextOrientation ?textBlock 1 ?rotation 0.0 ?justify "center")) 0.0000) (error "EdaKit: create pin failed"))
    (unless (axlDBCreatePadStack "EK_d0602d2ede6e998f574d" nil (list (make_axlPadStackPad ?layer "TOP" ?type 'REGULAR ?figure 'RECTANGLE ?figureSize 0.8500:0.2000) (make_axlPadStackPad ?layer "SOLDERMASK_TOP" ?type 'REGULAR ?figure 'RECTANGLE ?figureSize 0.8500:0.2000) (make_axlPadStackPad ?layer "PASTEMASK_TOP" ?type 'REGULAR ?figure 'RECTANGLE ?figureSize 0.8500:0.2000))) (error "EdaKit: create padstack failed"))
    (unless (isFile "E:/outputs/edakit/samples/C2040/EK_d0602d2ede6e998f574d.pad")
    (unless (axlPadstackToDisk "EK_d0602d2ede6e998f574d" "E:/outputs/edakit/samples/C2040/EK_d0602d2ede6e998f574d.pad") (error "EdaKit: save padstack failed"))
    )
    (unless (axlDBCreatePin "EK_d0602d2ede6e998f574d" -3.4249:-1.0000 (make_axlPinText ?number "5" ?offset 0:0 ?text (make_axlTextOrientation ?textBlock 1 ?rotation 0.0 ?justify "center")) 0.0000) (error "EdaKit: create pin failed"))
    (unless (axlDBCreatePadStack "EK_783398b5f17f617a560e" nil (list (make_axlPadStackPad ?layer "TOP" ?type 'REGULAR ?figure 'RECTANGLE ?figureSize 0.8500:0.2000) (make_axlPadStackPad ?layer "SOLDERMASK_TOP" ?type 'REGULAR ?figure 'RECTANGLE ?figureSize 0.8500:0.2000) (make_axlPadStackPad ?layer "PASTEMASK_TOP" ?type 'REGULAR ?figure 'RECTANGLE ?figureSize 0.8500:0.2000))) (error "EdaKit: create padstack failed"))
    (unless (isFile "E:/outputs/edakit/samples/C2040/EK_783398b5f17f617a560e.pad")
    (unless (axlPadstackToDisk "EK_783398b5f17f617a560e" "E:/outputs/edakit/samples/C2040/EK_783398b5f17f617a560e.pad") (error "EdaKit: save padstack failed"))
    )
    (unless (axlDBCreatePin "EK_783398b5f17f617a560e" -3.4249:-1.3998 (make_axlPinText ?number "4" ?offset 0:0 ?text (make_axlTextOrientation ?textBlock 1 ?rotation 0.0 ?justify "center")) 0.0000) (error "EdaKit: create pin failed"))
    (unless (axlDBCreatePadStack "EK_ca1d062cf01323b14982" nil (list (make_axlPadStackPad ?layer "TOP" ?type 'REGULAR ?figure 'RECTANGLE ?figureSize 0.8500:0.2000) (make_axlPadStackPad ?layer "SOLDERMASK_TOP" ?type 'REGULAR ?figure 'RECTANGLE ?figureSize 0.8500:0.2000) (make_axlPadStackPad ?layer "PASTEMASK_TOP" ?type 'REGULAR ?figure 'RECTANGLE ?figureSize 0.8500:0.2000))) (error "EdaKit: create padstack failed"))
    (unless (isFile "E:/outputs/edakit/samples/C2040/EK_ca1d062cf01323b14982.pad")
    (unless (axlPadstackToDisk "EK_ca1d062cf01323b14982" "E:/outputs/edakit/samples/C2040/EK_ca1d062cf01323b14982.pad") (error "EdaKit: save padstack failed"))
    )
    (unless (axlDBCreatePin "EK_ca1d062cf01323b14982" -3.4249:-1.7998 (make_axlPinText ?number "3" ?offset 0:0 ?text (make_axlTextOrientation ?textBlock 1 ?rotation 0.0 ?justify "center")) 0.0000) (error "EdaKit: create pin failed"))
    (unless (axlDBCreatePadStack "EK_6551c02358935fdb200b" nil (list (make_axlPadStackPad ?layer "TOP" ?type 'REGULAR ?figure 'RECTANGLE ?figureSize 0.8500:0.2000) (make_axlPadStackPad ?layer "SOLDERMASK_TOP" ?type 'REGULAR ?figure 'RECTANGLE ?figureSize 0.8500:0.2000) (make_axlPadStackPad ?layer "PASTEMASK_TOP" ?type 'REGULAR ?figure 'RECTANGLE ?figureSize 0.8500:0.2000))) (error "EdaKit: create padstack failed"))
    (unless (isFile "E:/outputs/edakit/samples/C2040/EK_6551c02358935fdb200b.pad")
    (unless (axlPadstackToDisk "EK_6551c02358935fdb200b" "E:/outputs/edakit/samples/C2040/EK_6551c02358935fdb200b.pad") (error "EdaKit: save padstack failed"))
    )
    (unless (axlDBCreatePin "EK_6551c02358935fdb200b" -3.4249:-2.1999 (make_axlPinText ?number "2" ?offset 0:0 ?text (make_axlTextOrientation ?textBlock 1 ?rotation 0.0 ?justify "center")) 0.0000) (error "EdaKit: create pin failed"))
    (unless (axlDBCreatePadStack "EK_6d1c998cfab7b618076e" nil (list (make_axlPadStackPad ?layer "TOP" ?type 'REGULAR ?figure 'RECTANGLE ?figureSize 0.8500:0.2000) (make_axlPadStackPad ?layer "SOLDERMASK_TOP" ?type 'REGULAR ?figure 'RECTANGLE ?figureSize 0.8500:0.2000) (make_axlPadStackPad ?layer "PASTEMASK_TOP" ?type 'REGULAR ?figure 'RECTANGLE ?figureSize 0.8500:0.2000))) (error "EdaKit: create padstack failed"))
    (unless (isFile "E:/outputs/edakit/samples/C2040/EK_6d1c998cfab7b618076e.pad")
    (unless (axlPadstackToDisk "EK_6d1c998cfab7b618076e" "E:/outputs/edakit/samples/C2040/EK_6d1c998cfab7b618076e.pad") (error "EdaKit: save padstack failed"))
    )
    (unless (axlDBCreatePin "EK_6d1c998cfab7b618076e" -3.4249:-2.5999 (make_axlPinText ?number "1" ?offset 0:0 ?text (make_axlTextOrientation ?textBlock 1 ?rotation 0.0 ?justify "center")) 0.0000) (error "EdaKit: create pin failed"))
    (unless (axlDBCreateLine (list -3.2410:-3.4999 -3.2410:-3.4030 -3.5001:-3.1439) 0.2540 "PACKAGE GEOMETRY/SILKSCREEN_TOP") (error "EdaKit: line failed"))
    (unless (axlDBCreateLine (list -3.5001:-2.9311 -2.9312:-3.4999) 0.2540 "PACKAGE GEOMETRY/SILKSCREEN_TOP") (error "EdaKit: line failed"))
    (unless (axlDBCreateLine (list -3.5001:-2.9311 -3.5001:-3.4999) 0.2540 "PACKAGE GEOMETRY/SILKSCREEN_TOP") (error "EdaKit: line failed"))
    (unless (axlDBCreateLine (list -2.9312:3.5000 -3.4000:3.5000 -3.5001:3.5000 -3.5001:2.9312) 0.2540 "PACKAGE GEOMETRY/SILKSCREEN_TOP") (error "EdaKit: line failed"))
    (unless (axlDBCreateLine (list 3.4999:2.9312 3.4999:3.5000 2.9311:3.5000) 0.2540 "PACKAGE GEOMETRY/SILKSCREEN_TOP") (error "EdaKit: line failed"))
    (unless (axlDBCreateLine (list 2.9311:-3.4999 3.4999:-3.4999 3.4999:-2.9311) 0.2540 "PACKAGE GEOMETRY/SILKSCREEN_TOP") (error "EdaKit: line failed"))
    (unless (axlDBCreateLine (list -3.5001:-3.4999 -2.9312:-3.4999) 0.2540 "PACKAGE GEOMETRY/SILKSCREEN_TOP") (error "EdaKit: line failed"))
    (unless (axlDBCreateLine (list -3.2410:-3.5000 -3.2410:-3.4032 -3.5001:-3.1441) 0.2540 "PACKAGE GEOMETRY/SILKSCREEN_TOP") (error "EdaKit: line failed"))
    (unless (axlDBCreateLine (list -3.5001:-2.9312 -2.9312:-3.5000) 0.2540 "PACKAGE GEOMETRY/SILKSCREEN_TOP") (error "EdaKit: line failed"))
    (unless (axlDBCreateLine (list -3.5001:-2.9312 -3.5001:-3.5000) 0.2540 "PACKAGE GEOMETRY/SILKSCREEN_TOP") (error "EdaKit: line failed"))
    (unless (axlDBCreateLine (list -2.9312:3.4999 -3.4000:3.4999 -3.5001:3.4999 -3.5001:2.9311) 0.2540 "PACKAGE GEOMETRY/SILKSCREEN_TOP") (error "EdaKit: line failed"))
    (unless (axlDBCreateLine (list 3.4999:2.9311 3.4999:3.4999 2.9311:3.4999) 0.2540 "PACKAGE GEOMETRY/SILKSCREEN_TOP") (error "EdaKit: line failed"))
    (unless (axlDBCreateLine (list 2.9311:-3.5000 3.4999:-3.5000 3.4999:-2.9312) 0.2540 "PACKAGE GEOMETRY/SILKSCREEN_TOP") (error "EdaKit: line failed"))
    (unless (axlDBCreateLine (list -3.5001:-3.5000 -2.9312:-3.5000) 0.2540 "PACKAGE GEOMETRY/SILKSCREEN_TOP") (error "EdaKit: line failed"))
    (unless (axlDBCreateCircle (list -3.5001:-3.5001 0.0300) 0.0600 "PACKAGE GEOMETRY/SILKSCREEN_TOP") (error "EdaKit: circle failed"))
    (unless (axlDBCreateCircle (list -3.8999:-2.6001 0.1270) 0.2540 "PACKAGE GEOMETRY/ASSEMBLY_TOP") (error "EdaKit: circle failed"))
    (unless (axlDBCreateCircle (list -3.8999:-2.5999 0.1270) 0.2540 "PACKAGE GEOMETRY/ASSEMBLY_TOP") (error "EdaKit: circle failed"))
    (unless (axlDBCreateCircle (list -4.0000:-3.7001 0.1270) 0.2540 "PACKAGE GEOMETRY/SILKSCREEN_TOP") (error "EdaKit: circle failed"))
    (unless (axlDBCreateCircle (list -4.0000:-3.7000 0.1270) 0.2540 "PACKAGE GEOMETRY/SILKSCREEN_TOP") (error "EdaKit: circle failed"))
    (unless (axlDBCreateShape (axlPathStart (list -2.7000:-3.0000 -2.7000:-3.5000 -2.5000:-3.5000 -2.5000:-3.0000)) t "PACKAGE GEOMETRY/ASSEMBLY_TOP") (error "EdaKit: solid region failed"))
    (unless (axlDBCreateShape (axlPathStart (list -2.3000:-3.0000 -2.3000:-3.5000 -2.1000:-3.5000 -2.1000:-3.0000)) t "PACKAGE GEOMETRY/ASSEMBLY_TOP") (error "EdaKit: solid region failed"))
    (unless (axlDBCreateShape (axlPathStart (list -1.9000:-3.0000 -1.9000:-3.5000 -1.7000:-3.5000 -1.7000:-3.0000)) t "PACKAGE GEOMETRY/ASSEMBLY_TOP") (error "EdaKit: solid region failed"))
    (unless (axlDBCreateShape (axlPathStart (list -1.5000:-3.0000 -1.5000:-3.5000 -1.3000:-3.5000 -1.3000:-3.0000)) t "PACKAGE GEOMETRY/ASSEMBLY_TOP") (error "EdaKit: solid region failed"))
    (unless (axlDBCreateShape (axlPathStart (list -1.1000:-3.0000 -1.1000:-3.5000 -0.9000:-3.5000 -0.9000:-3.0000)) t "PACKAGE GEOMETRY/ASSEMBLY_TOP") (error "EdaKit: solid region failed"))
    (unless (axlDBCreateShape (axlPathStart (list -0.7000:-3.0000 -0.7000:-3.5000 -0.5000:-3.5000 -0.5000:-3.0000)) t "PACKAGE GEOMETRY/ASSEMBLY_TOP") (error "EdaKit: solid region failed"))
    (unless (axlDBCreateShape (axlPathStart (list -0.3001:-3.0000 -0.3001:-3.5000 -0.1001:-3.5000 -0.1001:-3.0000)) t "PACKAGE GEOMETRY/ASSEMBLY_TOP") (error "EdaKit: solid region failed"))
    (unless (axlDBCreateShape (axlPathStart (list 0.0999:-3.0000 0.0999:-3.5000 0.2999:-3.5000 0.2999:-3.0000)) t "PACKAGE GEOMETRY/ASSEMBLY_TOP") (error "EdaKit: solid region failed"))
    (unless (axlDBCreateShape (axlPathStart (list 0.4999:-3.0000 0.4999:-3.5000 0.6999:-3.5000 0.6999:-3.0000)) t "PACKAGE GEOMETRY/ASSEMBLY_TOP") (error "EdaKit: solid region failed"))
    (unless (axlDBCreateShape (axlPathStart (list 0.8999:-3.0000 0.8999:-3.5000 1.0999:-3.5000 1.0999:-3.0000)) t "PACKAGE GEOMETRY/ASSEMBLY_TOP") (error "EdaKit: solid region failed"))
    (unless (axlDBCreateShape (axlPathStart (list 1.2999:-3.0000 1.2999:-3.5000 1.4999:-3.5000 1.4999:-3.0000)) t "PACKAGE GEOMETRY/ASSEMBLY_TOP") (error "EdaKit: solid region failed"))
    (unless (axlDBCreateShape (axlPathStart (list 1.6999:-3.0000 1.6999:-3.5000 1.8999:-3.5000 1.8999:-3.0000)) t "PACKAGE GEOMETRY/ASSEMBLY_TOP") (error "EdaKit: solid region failed"))
    (unless (axlDBCreateShape (axlPathStart (list 2.0999:-3.0000 2.0999:-3.5000 2.2999:-3.5000 2.2999:-3.0000)) t "PACKAGE GEOMETRY/ASSEMBLY_TOP") (error "EdaKit: solid region failed"))
    (unless (axlDBCreateShape (axlPathStart (list 2.4999:-3.0000 2.4999:-3.5000 2.6999:-3.5000 2.6999:-3.0000)) t "PACKAGE GEOMETRY/ASSEMBLY_TOP") (error "EdaKit: solid region failed"))
    (unless (axlDBCreateShape (axlPathStart (list 3.4999:-2.5000 2.9999:-2.5000 2.9999:-2.7000 3.4999:-2.7000)) t "PACKAGE GEOMETRY/ASSEMBLY_TOP") (error "EdaKit: solid region failed"))
    (unless (axlDBCreateShape (axlPathStart (list 3.4999:-2.1000 2.9999:-2.1000 2.9999:-2.3000 3.4999:-2.3000)) t "PACKAGE GEOMETRY/ASSEMBLY_TOP") (error "EdaKit: solid region failed"))
    (unless (axlDBCreateShape (axlPathStart (list 3.4999:-1.7000 2.9999:-1.7000 2.9999:-1.9000 3.4999:-1.9000)) t "PACKAGE GEOMETRY/ASSEMBLY_TOP") (error "EdaKit: solid region failed"))
    (unless (axlDBCreateShape (axlPathStart (list 3.4999:-1.3000 2.9999:-1.3000 2.9999:-1.5000 3.4999:-1.5000)) t "PACKAGE GEOMETRY/ASSEMBLY_TOP") (error "EdaKit: solid region failed"))
    (unless (axlDBCreateShape (axlPathStart (list 3.4999:-0.9000 2.9999:-0.9000 2.9999:-1.1000 3.4999:-1.1000)) t "PACKAGE GEOMETRY/ASSEMBLY_TOP") (error "EdaKit: solid region failed"))
    (unless (axlDBCreateShape (axlPathStart (list 3.4999:-0.5000 2.9999:-0.5000 2.9999:-0.7000 3.4999:-0.7000)) t "PACKAGE GEOMETRY/ASSEMBLY_TOP") (error "EdaKit: solid region failed"))
    (unless (axlDBCreateShape (axlPathStart (list 3.4999:-0.1001 2.9999:-0.1001 2.9999:-0.3001 3.4999:-0.3001)) t "PACKAGE GEOMETRY/ASSEMBLY_TOP") (error "EdaKit: solid region failed"))
    (unless (axlDBCreateShape (axlPathStart (list 3.4999:0.2999 2.9999:0.2999 2.9999:0.0999 3.4999:0.0999)) t "PACKAGE GEOMETRY/ASSEMBLY_TOP") (error "EdaKit: solid region failed"))
    (unless (axlDBCreateShape (axlPathStart (list 3.4999:0.6999 2.9999:0.6999 2.9999:0.4999 3.4999:0.4999)) t "PACKAGE GEOMETRY/ASSEMBLY_TOP") (error "EdaKit: solid region failed"))
    (unless (axlDBCreateShape (axlPathStart (list 3.4999:1.0999 2.9999:1.0999 2.9999:0.8999 3.4999:0.8999)) t "PACKAGE GEOMETRY/ASSEMBLY_TOP") (error "EdaKit: solid region failed"))
    (unless (axlDBCreateShape (axlPathStart (list 3.4999:1.4999 2.9999:1.4999 2.9999:1.2999 3.4999:1.2999)) t "PACKAGE GEOMETRY/ASSEMBLY_TOP") (error "EdaKit: solid region failed"))
    (unless (axlDBCreateShape (axlPathStart (list 3.4999:1.8999 2.9999:1.8999 2.9999:1.6999 3.4999:1.6999)) t "PACKAGE GEOMETRY/ASSEMBLY_TOP") (error "EdaKit: solid region failed"))
    (unless (axlDBCreateShape (axlPathStart (list 3.4999:2.2999 2.9999:2.2999 2.9999:2.0999 3.4999:2.0999)) t "PACKAGE GEOMETRY/ASSEMBLY_TOP") (error "EdaKit: solid region failed"))
    (unless (axlDBCreateShape (axlPathStart (list 3.4999:2.6999 2.9999:2.6999 2.9999:2.4999 3.4999:2.4999)) t "PACKAGE GEOMETRY/ASSEMBLY_TOP") (error "EdaKit: solid region failed"))
    (unless (axlDBCreateShape (axlPathStart (list 2.6999:3.0000 2.6999:3.5000 2.4999:3.5000 2.4999:3.0000)) t "PACKAGE GEOMETRY/ASSEMBLY_TOP") (error "EdaKit: solid region failed"))
    (unless (axlDBCreateShape (axlPathStart (list 2.2999:3.0000 2.2999:3.5000 2.0999:3.5000 2.0999:3.0000)) t "PACKAGE GEOMETRY/ASSEMBLY_TOP") (error "EdaKit: solid region failed"))
    (unless (axlDBCreateShape (axlPathStart (list 1.8999:3.0000 1.8999:3.5000 1.6999:3.5000 1.6999:3.0000)) t "PACKAGE GEOMETRY/ASSEMBLY_TOP") (error "EdaKit: solid region failed"))
    (unless (axlDBCreateShape (axlPathStart (list 1.4999:3.0000 1.4999:3.5000 1.2999:3.5000 1.2999:3.0000)) t "PACKAGE GEOMETRY/ASSEMBLY_TOP") (error "EdaKit: solid region failed"))
    (unless (axlDBCreateShape (axlPathStart (list 1.0999:3.0000 1.0999:3.5000 0.8999:3.5000 0.8999:3.0000)) t "PACKAGE GEOMETRY/ASSEMBLY_TOP") (error "EdaKit: solid region failed"))
    (unless (axlDBCreateShape (axlPathStart (list 0.6999:3.0000 0.6999:3.5000 0.4999:3.5000 0.4999:3.0000)) t "PACKAGE GEOMETRY/ASSEMBLY_TOP") (error "EdaKit: solid region failed"))
    (unless (axlDBCreateShape (axlPathStart (list 0.2999:3.0000 0.2999:3.5000 0.0999:3.5000 0.0999:3.0000)) t "PACKAGE GEOMETRY/ASSEMBLY_TOP") (error "EdaKit: solid region failed"))
    (unless (axlDBCreateShape (axlPathStart (list -0.1001:3.0000 -0.1001:3.5000 -0.3001:3.5000 -0.3001:3.0000)) t "PACKAGE GEOMETRY/ASSEMBLY_TOP") (error "EdaKit: solid region failed"))
    (unless (axlDBCreateShape (axlPathStart (list -0.5000:3.0000 -0.5000:3.5000 -0.7000:3.5000 -0.7000:3.0000)) t "PACKAGE GEOMETRY/ASSEMBLY_TOP") (error "EdaKit: solid region failed"))
    (unless (axlDBCreateShape (axlPathStart (list -0.9000:3.0000 -0.9000:3.5000 -1.1000:3.5000 -1.1000:3.0000)) t "PACKAGE GEOMETRY/ASSEMBLY_TOP") (error "EdaKit: solid region failed"))
    (unless (axlDBCreateShape (axlPathStart (list -1.3000:3.0000 -1.3000:3.5000 -1.5000:3.5000 -1.5000:3.0000)) t "PACKAGE GEOMETRY/ASSEMBLY_TOP") (error "EdaKit: solid region failed"))
    (unless (axlDBCreateShape (axlPathStart (list -1.7000:3.0000 -1.7000:3.5000 -1.9000:3.5000 -1.9000:3.0000)) t "PACKAGE GEOMETRY/ASSEMBLY_TOP") (error "EdaKit: solid region failed"))
    (unless (axlDBCreateShape (axlPathStart (list -2.1000:3.0000 -2.1000:3.5000 -2.3000:3.5000 -2.3000:3.0000)) t "PACKAGE GEOMETRY/ASSEMBLY_TOP") (error "EdaKit: solid region failed"))
    (unless (axlDBCreateShape (axlPathStart (list -2.5000:3.0000 -2.5000:3.5000 -2.7000:3.5000 -2.7000:3.0000)) t "PACKAGE GEOMETRY/ASSEMBLY_TOP") (error "EdaKit: solid region failed"))
    (unless (axlDBCreateShape (axlPathStart (list -3.5001:2.4999 -3.0001:2.4999 -3.0001:2.6999 -3.5001:2.6999)) t "PACKAGE GEOMETRY/ASSEMBLY_TOP") (error "EdaKit: solid region failed"))
    (unless (axlDBCreateShape (axlPathStart (list -3.5001:2.0999 -3.0001:2.0999 -3.0001:2.2999 -3.5001:2.2999)) t "PACKAGE GEOMETRY/ASSEMBLY_TOP") (error "EdaKit: solid region failed"))
    (unless (axlDBCreateShape (axlPathStart (list -3.5001:1.6999 -3.0001:1.6999 -3.0001:1.8999 -3.5001:1.8999)) t "PACKAGE GEOMETRY/ASSEMBLY_TOP") (error "EdaKit: solid region failed"))
    (unless (axlDBCreateShape (axlPathStart (list -3.5001:1.2999 -3.0001:1.2999 -3.0001:1.4999 -3.5001:1.4999)) t "PACKAGE GEOMETRY/ASSEMBLY_TOP") (error "EdaKit: solid region failed"))
    (unless (axlDBCreateShape (axlPathStart (list -3.5001:0.8999 -3.0001:0.8999 -3.0001:1.0999 -3.5001:1.0999)) t "PACKAGE GEOMETRY/ASSEMBLY_TOP") (error "EdaKit: solid region failed"))
    (unless (axlDBCreateShape (axlPathStart (list -3.5001:0.4999 -3.0001:0.4999 -3.0001:0.6999 -3.5001:0.6999)) t "PACKAGE GEOMETRY/ASSEMBLY_TOP") (error "EdaKit: solid region failed"))
    (unless (axlDBCreateShape (axlPathStart (list -3.5001:0.0999 -3.0001:0.0999 -3.0001:0.2999 -3.5001:0.2999)) t "PACKAGE GEOMETRY/ASSEMBLY_TOP") (error "EdaKit: solid region failed"))
    (unless (axlDBCreateShape (axlPathStart (list -3.5001:-0.3001 -3.0001:-0.3001 -3.0001:-0.1001 -3.5001:-0.1001)) t "PACKAGE GEOMETRY/ASSEMBLY_TOP") (error "EdaKit: solid region failed"))
    (unless (axlDBCreateShape (axlPathStart (list -3.5001:-0.7000 -3.0001:-0.7000 -3.0001:-0.5000 -3.5001:-0.5000)) t "PACKAGE GEOMETRY/ASSEMBLY_TOP") (error "EdaKit: solid region failed"))
    (unless (axlDBCreateShape (axlPathStart (list -3.5001:-1.1000 -3.0001:-1.1000 -3.0001:-0.9000 -3.5001:-0.9000)) t "PACKAGE GEOMETRY/ASSEMBLY_TOP") (error "EdaKit: solid region failed"))
    (unless (axlDBCreateShape (axlPathStart (list -3.5001:-1.5000 -3.0001:-1.5000 -3.0001:-1.3000 -3.5001:-1.3000)) t "PACKAGE GEOMETRY/ASSEMBLY_TOP") (error "EdaKit: solid region failed"))
    (unless (axlDBCreateShape (axlPathStart (list -3.5001:-1.9000 -3.0001:-1.9000 -3.0001:-1.7000 -3.5001:-1.7000)) t "PACKAGE GEOMETRY/ASSEMBLY_TOP") (error "EdaKit: solid region failed"))
    (unless (axlDBCreateShape (axlPathStart (list -3.5001:-2.3000 -3.0001:-2.3000 -3.0001:-2.1000 -3.5001:-2.1000)) t "PACKAGE GEOMETRY/ASSEMBLY_TOP") (error "EdaKit: solid region failed"))
    (unless (axlDBCreateShape (axlPathStart (list -3.5001:-2.7000 -3.0001:-2.7000 -3.0001:-2.5000 -3.5001:-2.5000)) t "PACKAGE GEOMETRY/ASSEMBLY_TOP") (error "EdaKit: solid region failed"))
    (unless (axlDBCreateShape (axlPathStart (list -1.5501:-1.5501 1.5500:-1.5501 1.5500:1.5500 -1.5501:1.5500)) t "PACKAGE GEOMETRY/ASSEMBLY_TOP") (error "EdaKit: solid region failed"))
    (unless (axlDBCreateShape (axlPathStart (list -1.5501:-1.5499 1.5500:-1.5499 1.5500:1.5501 -1.5501:1.5501)) t "PACKAGE GEOMETRY/ASSEMBLY_TOP") (error "EdaKit: solid region failed"))
    (unless (axlDBCreateShape (axlPathStart (list -3.5001:-2.6999 -3.0001:-2.6999 -3.0001:-2.4999 -3.5001:-2.4999)) t "PACKAGE GEOMETRY/ASSEMBLY_TOP") (error "EdaKit: solid region failed"))
    (unless (axlDBCreateShape (axlPathStart (list -3.5001:-2.2999 -3.0001:-2.2999 -3.0001:-2.0999 -3.5001:-2.0999)) t "PACKAGE GEOMETRY/ASSEMBLY_TOP") (error "EdaKit: solid region failed"))
    (unless (axlDBCreateShape (axlPathStart (list -3.5001:-1.8999 -3.0001:-1.8999 -3.0001:-1.6999 -3.5001:-1.6999)) t "PACKAGE GEOMETRY/ASSEMBLY_TOP") (error "EdaKit: solid region failed"))
    (unless (axlDBCreateShape (axlPathStart (list -3.5001:-1.4999 -3.0001:-1.4999 -3.0001:-1.2999 -3.5001:-1.2999)) t "PACKAGE GEOMETRY/ASSEMBLY_TOP") (error "EdaKit: solid region failed"))
    (unless (axlDBCreateShape (axlPathStart (list -3.5001:-1.0999 -3.0001:-1.0999 -3.0001:-0.8999 -3.5001:-0.8999)) t "PACKAGE GEOMETRY/ASSEMBLY_TOP") (error "EdaKit: solid region failed"))
    (unless (axlDBCreateShape (axlPathStart (list -3.5001:-0.6999 -3.0001:-0.6999 -3.0001:-0.4999 -3.5001:-0.4999)) t "PACKAGE GEOMETRY/ASSEMBLY_TOP") (error "EdaKit: solid region failed"))
    (unless (axlDBCreateShape (axlPathStart (list -3.5001:-0.2999 -3.0001:-0.2999 -3.0001:-0.0999 -3.5001:-0.0999)) t "PACKAGE GEOMETRY/ASSEMBLY_TOP") (error "EdaKit: solid region failed"))
    (unless (axlDBCreateShape (axlPathStart (list -3.5001:0.1001 -3.0001:0.1001 -3.0001:0.3001 -3.5001:0.3001)) t "PACKAGE GEOMETRY/ASSEMBLY_TOP") (error "EdaKit: solid region failed"))
    (unless (axlDBCreateShape (axlPathStart (list -3.5001:0.5001 -3.0001:0.5001 -3.0001:0.7001 -3.5001:0.7001)) t "PACKAGE GEOMETRY/ASSEMBLY_TOP") (error "EdaKit: solid region failed"))
    (unless (axlDBCreateShape (axlPathStart (list -3.5001:0.9001 -3.0001:0.9001 -3.0001:1.1001 -3.5001:1.1001)) t "PACKAGE GEOMETRY/ASSEMBLY_TOP") (error "EdaKit: solid region failed"))
    (unless (axlDBCreateShape (axlPathStart (list -3.5001:1.3001 -3.0001:1.3001 -3.0001:1.5001 -3.5001:1.5001)) t "PACKAGE GEOMETRY/ASSEMBLY_TOP") (error "EdaKit: solid region failed"))
    (unless (axlDBCreateShape (axlPathStart (list -3.5001:1.7001 -3.0001:1.7001 -3.0001:1.9001 -3.5001:1.9001)) t "PACKAGE GEOMETRY/ASSEMBLY_TOP") (error "EdaKit: solid region failed"))
    (unless (axlDBCreateShape (axlPathStart (list -3.5001:2.1001 -3.0001:2.1001 -3.0001:2.3001 -3.5001:2.3001)) t "PACKAGE GEOMETRY/ASSEMBLY_TOP") (error "EdaKit: solid region failed"))
    (unless (axlDBCreateShape (axlPathStart (list -3.5001:2.5001 -3.0001:2.5001 -3.0001:2.7001 -3.5001:2.7001)) t "PACKAGE GEOMETRY/ASSEMBLY_TOP") (error "EdaKit: solid region failed"))
    (unless (axlDBCreateShape (axlPathStart (list -2.5000:3.0001 -2.5000:3.5001 -2.7000:3.5001 -2.7000:3.0001)) t "PACKAGE GEOMETRY/ASSEMBLY_TOP") (error "EdaKit: solid region failed"))
    (unless (axlDBCreateShape (axlPathStart (list -2.1000:3.0001 -2.1000:3.5001 -2.3000:3.5001 -2.3000:3.0001)) t "PACKAGE GEOMETRY/ASSEMBLY_TOP") (error "EdaKit: solid region failed"))
    (unless (axlDBCreateShape (axlPathStart (list -1.7000:3.0001 -1.7000:3.5001 -1.9000:3.5001 -1.9000:3.0001)) t "PACKAGE GEOMETRY/ASSEMBLY_TOP") (error "EdaKit: solid region failed"))
    (unless (axlDBCreateShape (axlPathStart (list -1.3000:3.0001 -1.3000:3.5001 -1.5000:3.5001 -1.5000:3.0001)) t "PACKAGE GEOMETRY/ASSEMBLY_TOP") (error "EdaKit: solid region failed"))
    (unless (axlDBCreateShape (axlPathStart (list -0.9000:3.0001 -0.9000:3.5001 -1.1000:3.5001 -1.1000:3.0001)) t "PACKAGE GEOMETRY/ASSEMBLY_TOP") (error "EdaKit: solid region failed"))
    (unless (axlDBCreateShape (axlPathStart (list -0.5000:3.0001 -0.5000:3.5001 -0.7000:3.5001 -0.7000:3.0001)) t "PACKAGE GEOMETRY/ASSEMBLY_TOP") (error "EdaKit: solid region failed"))
    (unless (axlDBCreateShape (axlPathStart (list -0.1001:3.0001 -0.1001:3.5001 -0.3001:3.5001 -0.3001:3.0001)) t "PACKAGE GEOMETRY/ASSEMBLY_TOP") (error "EdaKit: solid region failed"))
    (unless (axlDBCreateShape (axlPathStart (list 0.2999:3.0001 0.2999:3.5001 0.0999:3.5001 0.0999:3.0001)) t "PACKAGE GEOMETRY/ASSEMBLY_TOP") (error "EdaKit: solid region failed"))
    (unless (axlDBCreateShape (axlPathStart (list 0.6999:3.0001 0.6999:3.5001 0.4999:3.5001 0.4999:3.0001)) t "PACKAGE GEOMETRY/ASSEMBLY_TOP") (error "EdaKit: solid region failed"))
    (unless (axlDBCreateShape (axlPathStart (list 1.0999:3.0001 1.0999:3.5001 0.8999:3.5001 0.8999:3.0001)) t "PACKAGE GEOMETRY/ASSEMBLY_TOP") (error "EdaKit: solid region failed"))
    (unless (axlDBCreateShape (axlPathStart (list 1.4999:3.0001 1.4999:3.5001 1.2999:3.5001 1.2999:3.0001)) t "PACKAGE GEOMETRY/ASSEMBLY_TOP") (error "EdaKit: solid region failed"))
    (unless (axlDBCreateShape (axlPathStart (list 1.8999:3.0001 1.8999:3.5001 1.6999:3.5001 1.6999:3.0001)) t "PACKAGE GEOMETRY/ASSEMBLY_TOP") (error "EdaKit: solid region failed"))
    (unless (axlDBCreateShape (axlPathStart (list 2.2999:3.0001 2.2999:3.5001 2.0999:3.5001 2.0999:3.0001)) t "PACKAGE GEOMETRY/ASSEMBLY_TOP") (error "EdaKit: solid region failed"))
    (unless (axlDBCreateShape (axlPathStart (list 2.6999:3.0001 2.6999:3.5001 2.4999:3.5001 2.4999:3.0001)) t "PACKAGE GEOMETRY/ASSEMBLY_TOP") (error "EdaKit: solid region failed"))
    (unless (axlDBCreateShape (axlPathStart (list 3.4999:2.7001 2.9999:2.7001 2.9999:2.5001 3.4999:2.5001)) t "PACKAGE GEOMETRY/ASSEMBLY_TOP") (error "EdaKit: solid region failed"))
    (unless (axlDBCreateShape (axlPathStart (list 3.4999:2.3001 2.9999:2.3001 2.9999:2.1001 3.4999:2.1001)) t "PACKAGE GEOMETRY/ASSEMBLY_TOP") (error "EdaKit: solid region failed"))
    (unless (axlDBCreateShape (axlPathStart (list 3.4999:1.9001 2.9999:1.9001 2.9999:1.7001 3.4999:1.7001)) t "PACKAGE GEOMETRY/ASSEMBLY_TOP") (error "EdaKit: solid region failed"))
    (unless (axlDBCreateShape (axlPathStart (list 3.4999:1.5001 2.9999:1.5001 2.9999:1.3001 3.4999:1.3001)) t "PACKAGE GEOMETRY/ASSEMBLY_TOP") (error "EdaKit: solid region failed"))
    (unless (axlDBCreateShape (axlPathStart (list 3.4999:1.1001 2.9999:1.1001 2.9999:0.9001 3.4999:0.9001)) t "PACKAGE GEOMETRY/ASSEMBLY_TOP") (error "EdaKit: solid region failed"))
    (unless (axlDBCreateShape (axlPathStart (list 3.4999:0.7001 2.9999:0.7001 2.9999:0.5001 3.4999:0.5001)) t "PACKAGE GEOMETRY/ASSEMBLY_TOP") (error "EdaKit: solid region failed"))
    (unless (axlDBCreateShape (axlPathStart (list 3.4999:0.3001 2.9999:0.3001 2.9999:0.1001 3.4999:0.1001)) t "PACKAGE GEOMETRY/ASSEMBLY_TOP") (error "EdaKit: solid region failed"))
    (unless (axlDBCreateShape (axlPathStart (list 3.4999:-0.0999 2.9999:-0.0999 2.9999:-0.2999 3.4999:-0.2999)) t "PACKAGE GEOMETRY/ASSEMBLY_TOP") (error "EdaKit: solid region failed"))
    (unless (axlDBCreateShape (axlPathStart (list 3.4999:-0.4999 2.9999:-0.4999 2.9999:-0.6999 3.4999:-0.6999)) t "PACKAGE GEOMETRY/ASSEMBLY_TOP") (error "EdaKit: solid region failed"))
    (unless (axlDBCreateShape (axlPathStart (list 3.4999:-0.8999 2.9999:-0.8999 2.9999:-1.0999 3.4999:-1.0999)) t "PACKAGE GEOMETRY/ASSEMBLY_TOP") (error "EdaKit: solid region failed"))
    (unless (axlDBCreateShape (axlPathStart (list 3.4999:-1.2999 2.9999:-1.2999 2.9999:-1.4999 3.4999:-1.4999)) t "PACKAGE GEOMETRY/ASSEMBLY_TOP") (error "EdaKit: solid region failed"))
    (unless (axlDBCreateShape (axlPathStart (list 3.4999:-1.6999 2.9999:-1.6999 2.9999:-1.8999 3.4999:-1.8999)) t "PACKAGE GEOMETRY/ASSEMBLY_TOP") (error "EdaKit: solid region failed"))
    (unless (axlDBCreateShape (axlPathStart (list 3.4999:-2.0999 2.9999:-2.0999 2.9999:-2.2999 3.4999:-2.2999)) t "PACKAGE GEOMETRY/ASSEMBLY_TOP") (error "EdaKit: solid region failed"))
    (unless (axlDBCreateShape (axlPathStart (list 3.4999:-2.4999 2.9999:-2.4999 2.9999:-2.6999 3.4999:-2.6999)) t "PACKAGE GEOMETRY/ASSEMBLY_TOP") (error "EdaKit: solid region failed"))
    (unless (axlDBCreateShape (axlPathStart (list 2.4999:-2.9999 2.4999:-3.4999 2.6999:-3.4999 2.6999:-2.9999)) t "PACKAGE GEOMETRY/ASSEMBLY_TOP") (error "EdaKit: solid region failed"))
    (unless (axlDBCreateShape (axlPathStart (list 2.0999:-2.9999 2.0999:-3.4999 2.2999:-3.4999 2.2999:-2.9999)) t "PACKAGE GEOMETRY/ASSEMBLY_TOP") (error "EdaKit: solid region failed"))
    (unless (axlDBCreateShape (axlPathStart (list 1.6999:-2.9999 1.6999:-3.4999 1.8999:-3.4999 1.8999:-2.9999)) t "PACKAGE GEOMETRY/ASSEMBLY_TOP") (error "EdaKit: solid region failed"))
    (unless (axlDBCreateShape (axlPathStart (list 1.2999:-2.9999 1.2999:-3.4999 1.4999:-3.4999 1.4999:-2.9999)) t "PACKAGE GEOMETRY/ASSEMBLY_TOP") (error "EdaKit: solid region failed"))
    (unless (axlDBCreateShape (axlPathStart (list 0.8999:-2.9999 0.8999:-3.4999 1.0999:-3.4999 1.0999:-2.9999)) t "PACKAGE GEOMETRY/ASSEMBLY_TOP") (error "EdaKit: solid region failed"))
    (unless (axlDBCreateShape (axlPathStart (list 0.4999:-2.9999 0.4999:-3.4999 0.6999:-3.4999 0.6999:-2.9999)) t "PACKAGE GEOMETRY/ASSEMBLY_TOP") (error "EdaKit: solid region failed"))
    (unless (axlDBCreateShape (axlPathStart (list 0.0999:-2.9999 0.0999:-3.4999 0.2999:-3.4999 0.2999:-2.9999)) t "PACKAGE GEOMETRY/ASSEMBLY_TOP") (error "EdaKit: solid region failed"))
    (unless (axlDBCreateShape (axlPathStart (list -0.3001:-2.9999 -0.3001:-3.4999 -0.1001:-3.4999 -0.1001:-2.9999)) t "PACKAGE GEOMETRY/ASSEMBLY_TOP") (error "EdaKit: solid region failed"))
    (unless (axlDBCreateShape (axlPathStart (list -0.7000:-2.9999 -0.7000:-3.4999 -0.5000:-3.4999 -0.5000:-2.9999)) t "PACKAGE GEOMETRY/ASSEMBLY_TOP") (error "EdaKit: solid region failed"))
    (unless (axlDBCreateShape (axlPathStart (list -1.1000:-2.9999 -1.1000:-3.4999 -0.9000:-3.4999 -0.9000:-2.9999)) t "PACKAGE GEOMETRY/ASSEMBLY_TOP") (error "EdaKit: solid region failed"))
    (unless (axlDBCreateShape (axlPathStart (list -1.5000:-2.9999 -1.5000:-3.4999 -1.3000:-3.4999 -1.3000:-2.9999)) t "PACKAGE GEOMETRY/ASSEMBLY_TOP") (error "EdaKit: solid region failed"))
    (unless (axlDBCreateShape (axlPathStart (list -1.9000:-2.9999 -1.9000:-3.4999 -1.7000:-3.4999 -1.7000:-2.9999)) t "PACKAGE GEOMETRY/ASSEMBLY_TOP") (error "EdaKit: solid region failed"))
    (unless (axlDBCreateShape (axlPathStart (list -2.3000:-2.9999 -2.3000:-3.4999 -2.1000:-3.4999 -2.1000:-2.9999)) t "PACKAGE GEOMETRY/ASSEMBLY_TOP") (error "EdaKit: solid region failed"))
    (unless (axlDBCreateShape (axlPathStart (list -2.7000:-2.9999 -2.7000:-3.4999 -2.5000:-3.4999 -2.5000:-2.9999)) t "PACKAGE GEOMETRY/ASSEMBLY_TOP") (error "EdaKit: solid region failed"))
    (unless (axlDBCreateShape (axlPathStart (list 3.5001:3.4999 -3.4999:3.4999 -3.4999:-3.5001 3.5001:-3.5001)) t "PACKAGE GEOMETRY/ASSEMBLY_TOP") (error "EdaKit: solid region failed"))
    (unless (axlDBCreateShape (axlPathStart (list 3.5001:3.5001 -3.4999:3.5001 -3.4999:-3.4999 3.5001:-3.4999)) t "PACKAGE GEOMETRY/ASSEMBLY_TOP") (error "EdaKit: solid region failed"))
    (unless (axlDBCreateRectangle (list -4.3270:-4.0499 4.0499:4.0502) t "PACKAGE GEOMETRY/PLACE_BOUND_TOP") (error "EdaKit: place bound failed"))
    (unless (axlDBCreateText "U*" -0.1385:5.0502 (make_axlTextOrientation ?textBlock "1" ?rotation 0.0 ?justify "center") "REF DES/SILKSCREEN_TOP" nil) (error "EdaKit: reference designator failed"))
    (unless (axlDBCreateText "U*" -0.1385:5.0502 (make_axlTextOrientation ?textBlock "1" ?rotation 0.0 ?justify "center") "REF DES/ASSEMBLY_TOP" nil) (error "EdaKit: reference designator failed"))
    (unless (axlSaveDesign ?noMru t) (error "EdaKit: save design failed"))
    (unless (axlCompileSymbol ?symbol "E:/outputs/edakit/samples/C2040/LQFN-56_L7.0-W7.0-P0.4-EP") (error "EdaKit: compile package failed"))
    t
  )
)

(lcsc_build_footprint)
